ADE simulation setup
Test ECE555_AND2_TEST_1: ECE555/AND2_TEST/schematic, simulator hspiceD
Run mode: Single Run, Sweeps and Corners
