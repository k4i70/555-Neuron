ADE simulation setup
Run mode: Single Run, Sweeps and Corners
Tests:
  ECE555_AND2_TEST_1: ECE555/AND2_TEST/schematic, simulator hspiceD
