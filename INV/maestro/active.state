ADE simulation setup
Test ECE555_INV_1: ECE555/INV/schematic, simulator hspiceD
Run mode: Single Run, Sweeps and Corners
