************************************************************************
* auCdl Netlist:
*
* Library Name:  555-Neuron
* Top Cell Name: NEURON
* View Name:     schematic
* Netlisted on:  Nov 15 20:16:28 2026
************************************************************************

*.EQUATION
*.SCALE METER
*.MEGA
.PARAM

************************************************************************
* Library Name: 555-Neuron
* Cell Name:    NAND2
* View Name:    schematic
************************************************************************

.SUBCKT NAND2 A B VDD VSS Y
*.PININFO A:I B:I Y:O VDD:B VSS:B
MM0 Y A net35 VSS nmos_rvt w=54n l=20n nfin=2
MM1 net35 B VSS VSS nmos_rvt w=54n l=20n nfin=2
MM4 Y B VDD VDD pmos_rvt w=81n l=20n nfin=3
MM3 Y A VDD VDD pmos_rvt w=81n l=20n nfin=3
.ENDS

.SUBCKT NAND2X A B VDD VSS Y
*.PININFO A:I B:I Y:O VDD:B VSS:B
MM0 Y A net35 VSS nmos_rvt w=27n l=20n nfin=1
MM1 net35 B VSS VSS nmos_rvt w=27n l=20n nfin=1
MM4 Y B VDD VDD pmos_rvt w=54n l=20n nfin=2
MM3 Y A VDD VDD pmos_rvt w=54n l=20n nfin=2
.ENDS

.SUBCKT NAND2Z A B VDD VSS Y
*.PININFO A:I B:I Y:O VDD:B VSS:B
MM0 Y A net35 VSS nmos_rvt w=108n l=20n nfin=4
MM1 net35 B VSS VSS nmos_rvt w=108n l=20n nfin=4
MM4 Y B VDD VDD pmos_rvt w=81n l=20n nfin=3
MM3 Y A VDD VDD pmos_rvt w=81n l=20n nfin=3
.ENDS

************************************************************************
* Library Name: 555-Neuron
* Cell Name:    OAI21
* View Name:    schematic
************************************************************************

.SUBCKT OAI21 A B C VDD VSS Y
*.PININFO A:I B:I C:I Y:O VDD:B VSS:B
MM2 net3 C VSS VSS nmos_rvt w=54n l=20n nfin=2
MM1 net3 B VSS VSS nmos_rvt w=54n l=20n nfin=2
MM0 Y A net3 VSS nmos_rvt w=54n l=20n nfin=2
MM5 Y B net17 VDD pmos_rvt w=81n l=20n nfin=3
MM4 net17 C VDD VDD pmos_rvt w=81n l=20n nfin=3
MM3 Y A VDD VDD pmos_rvt w=81n l=20n nfin=3
.ENDS

************************************************************************
* Library Name: 555-Neuron
* Cell Name:    FRONT
* View Name:    schematic
************************************************************************

.SUBCKT FRONT VDD VSS W0 W1 X0 X1 XN Z
*.PININFO W0:I W1:I X0:I X1:I XN:O Z:O VDD:B VSS:B
XI1 X0 W0 VDD VSS Z / NAND2Z
XI0 X1 W1 VDD VSS net5 / NAND2X
XI2 net5 X1 W1 VDD VSS XN / OAI21
.ENDS

************************************************************************
* Library Name: 555-Neuron
* Cell Name:    INV
* View Name:    schematic
************************************************************************

.SUBCKT INV IN OUT VDD VSS
*.PININFO IN:I OUT:O VDD:B VSS:B
MM0 OUT IN VSS VSS nmos_rvt w=54n l=20n nfin=2
MM1 OUT IN VDD VDD pmos_rvt w=81n l=20n nfin=3
.ENDS

************************************************************************
* Library Name: 555-Neuron
* Cell Name:    OAI221
* View Name:    schematic
************************************************************************

.SUBCKT OAI221 A B C D E VDD VSS Y
*.PININFO A:I B:I C:I D:I E:I Y:O VDD:B VSS:B
MM4 Y E VDD VDD pmos_rvt w=81n l=20n nfin=3
MM3 Y A net1 VDD pmos_rvt w=81n l=20n nfin=3
MM2 Y C net5 VDD pmos_rvt w=81n l=20n nfin=3
MM1 net5 D VDD VDD pmos_rvt w=81n l=20n nfin=3
MM0 net1 B VDD VDD pmos_rvt w=81n l=20n nfin=3
MM9 net23 D net27 VSS nmos_rvt w=108n l=20n nfin=4
MM8 Y B net23 VSS nmos_rvt w=54n l=20n nfin=2
MM7 net27 E VSS VSS nmos_rvt w=108n l=20n nfin=4
MM6 net23 C net27 VSS nmos_rvt w=108n l=20n nfin=4
MM5 Y A net23 VSS nmos_rvt w=54n l=20n nfin=2
.ENDS

************************************************************************
* Library Name: 555-Neuron
* Cell Name:    MAJI5M
* View Name:    schematic
************************************************************************

.SUBCKT MAJI5M A B C VDD VSS Y
*.PININFO A:I B:I C:I Y:O VDD:B VSS:B
MM8 Y C net3 VSS nmos_rvt w=54n l=20n nfin=2
MM5 Y A net40 VSS nmos_rvt w=54n l=20n nfin=2
MM9 net3 A VSS VSS nmos_rvt w=54n l=20n nfin=2
MM6 net40 B VSS VSS nmos_rvt w=54n l=20n nfin=2
MM7 net3 B VSS VSS nmos_rvt w=54n l=20n nfin=2
MM4 net42 B VDD VDD pmos_rvt w=81n l=20n nfin=3
MM1 net42 A VDD VDD pmos_rvt w=81n l=20n nfin=3
MM0 net43 B VDD VDD pmos_rvt w=81n l=20n nfin=3
MM3 Y A net43 VDD pmos_rvt w=81n l=20n nfin=3
MM2 Y C net42 VDD pmos_rvt w=81n l=20n nfin=3
.ENDS

.SUBCKT MAJN A B C VDD VSS Y
*.PININFO A:I B:I C:I Y:O VDD:B VSS:B
MM8 Y C net3 VSS nmos_rvt w=27n l=20n nfin=1
MM5 Y A net40 VSS nmos_rvt w=27n l=20n nfin=1
MM9 net3 A VSS VSS nmos_rvt w=27n l=20n nfin=1
MM6 net40 B VSS VSS nmos_rvt w=27n l=20n nfin=1
MM7 net3 B VSS VSS nmos_rvt w=27n l=20n nfin=1
MM4 net42 B VDD VDD pmos_rvt w=54n l=20n nfin=2
MM1 net42 A VDD VDD pmos_rvt w=54n l=20n nfin=2
MM0 net43 B VDD VDD pmos_rvt w=54n l=20n nfin=2
MM3 Y A net43 VDD pmos_rvt w=54n l=20n nfin=2
MM2 Y C net42 VDD pmos_rvt w=54n l=20n nfin=2
.ENDS

************************************************************************
* Library Name: 555-Neuron
* Cell Name:    NCNT
* View Name:    schematic
************************************************************************

.SUBCKT NCNT B1 R1 R2 VDD VSS XNA XNB ZA ZB
*.PININFO B1:I XNA:I XNB:I ZA:I ZB:I R1:O R2:O VDD:B VSS:B
XI0 B1 net3 VDD VSS / INV
XI1 XNA ZA XNB ZB net3 VDD VSS R1 / OAI221
XI2 XNA net3 XNB VDD VSS R2 / MAJN
.ENDS

************************************************************************
* Library Name: 555-Neuron
* Cell Name:    NAND3
* View Name:    schematic
************************************************************************

.SUBCKT NAND3 A B C VDD VSS Y
*.PININFO A:I B:I C:I Y:O VDD:B VSS:B
MM2 net7 C VSS VSS nmos_rvt w=27n l=20n nfin=1
MM1 net3 B net7 VSS nmos_rvt w=27n l=20n nfin=1
MM0 Y A net3 VSS nmos_rvt w=27n l=20n nfin=1
MM5 Y C VDD VDD pmos_rvt w=54n l=20n nfin=2
MM4 Y B VDD VDD pmos_rvt w=54n l=20n nfin=2
MM3 Y A VDD VDD pmos_rvt w=54n l=20n nfin=2
.ENDS

************************************************************************
* Library Name: 555-Neuron
* Cell Name:    NOR3
* View Name:    schematic
************************************************************************

.SUBCKT NOR3 A B C VDD VSS Y
*.PININFO A:I B:I C:I Y:O VDD:B VSS:B
MM2 Y A net5 VDD pmos_rvt w=54n l=20n nfin=2
MM1 net5 B net1 VDD pmos_rvt w=54n l=20n nfin=2
MM0 net1 C VDD VDD pmos_rvt w=54n l=20n nfin=2
MM5 Y C VSS VSS nmos_rvt w=27n l=20n nfin=1
MM4 Y B VSS VSS nmos_rvt w=27n l=20n nfin=1
MM3 Y A VSS VSS nmos_rvt w=27n l=20n nfin=1
.ENDS

************************************************************************
* Library Name: 555-Neuron
* Cell Name:    UCNT
* View Name:    schematic
************************************************************************

.SUBCKT UCNT B0 V1 V2 V3 VDD VSS ZA ZB
*.PININFO B0:I ZA:I ZB:I V1:O V2:O V3:O VDD:B VSS:B
XI0 B0 net3 VDD VSS / INV
XI1 ZA ZB net3 VDD VSS V1 / NAND3
XI2 ZA net3 ZB VDD VSS V2 / MAJI5M
XI3 ZA ZB net3 VDD VSS V3 / NOR3
.ENDS

************************************************************************
* Library Name: 555-Neuron
* Cell Name:    NOR
* View Name:    schematic
************************************************************************

.SUBCKT NOR A B VDD VSS Y
*.PININFO A:I B:I Y:O VDD:B VSS:B
MM2 Y B VSS VSS nmos_rvt w=54n l=20n nfin=2
MM0 Y A VSS VSS nmos_rvt w=54n l=20n nfin=2
MM3 Y B net5 VDD pmos_rvt w=81n l=20n nfin=3
MM1 net5 A VDD VDD pmos_rvt w=81n l=20n nfin=3
.ENDS

************************************************************************
* Library Name: 555-Neuron
* Cell Name:    OAI32
* View Name:    schematic
************************************************************************

.SUBCKT OAI32 A B C D E VDD VSS Y
*.PININFO A:I B:I C:I D:I E:I Y:O VDD:B VSS:B
MM8 net40 E VSS VSS nmos_rvt w=108n l=20n nfin=4
MM5 Y C net40 VSS nmos_rvt w=54n l=20n nfin=2
MM9 Y B net40 VSS nmos_rvt w=54n l=20n nfin=2
MM6 Y A net40 VSS nmos_rvt w=54n l=20n nfin=2
MM7 net40 D VSS VSS nmos_rvt w=54n l=20n nfin=2
MM4 Y A net9 VDD pmos_rvt w=81n l=20n nfin=3
MM1 net42 E VDD VDD pmos_rvt w=81n l=20n nfin=3
MM0 net39 C VDD VDD pmos_rvt w=162n l=20n nfin=6
MM3 net9 B net39 VDD pmos_rvt w=162n l=20n nfin=6
MM2 Y D net42 VDD pmos_rvt w=81n l=20n nfin=3
.ENDS

************************************************************************
* Library Name: 555-Neuron
* Cell Name:    OUT
* View Name:    schematic
************************************************************************

.SUBCKT OUT R1 R2 V1 V2 V3 VDD VSS Z0 Z1
*.PININFO R1:I R2:I V1:I V2:I V3:I Z0:O Z1:O VDD:B VSS:B
XI0 R1 net1 VDD VSS Z1 / NOR
XI1 R1 net9 V2 R2 net6 VDD VSS Z0 / OAI32
XI4 V3 net6 VDD VSS / INV
XI3 V1 net9 VDD VSS / INV
XI2 V2 net1 VDD VSS / INV
.ENDS

************************************************************************
* Library Name: 555-Neuron
* Cell Name:    NEURON
* View Name:    schematic
************************************************************************

.SUBCKT NEURON B0 B1 VDD VSS WA0 WA1 WB0 WB1 XA0 XA1 XB0 XB1 Z0 Z1
*.PININFO B0:I B1:I WA0:I WA1:I WB0:I WB1:I XA0:I XA1:I XB0:I XB1:I Z0:O Z1:O
*.PININFO VDD:B VSS:B
XI1 VDD VSS WB0 WB1 XB0 XB1 net14 net13 / FRONT
XI0 VDD VSS WA0 WA1 XA0 XA1 net6 net5 / FRONT
XI2 B1 R1 R2 VDD VSS net6 net14 net5 net13 / NCNT
XI3 B0 V1 V2 V3 VDD VSS net5 net13 / UCNT
XI4 R1 R2 V1 V2 V3 VDD VSS Z0 Z1 / OUT
.ENDS
