* NEURON exhaustive transition testbench (generated, HSPICE)
* POST=1 binary .tr0; POST_VERSION=2001 -> double precision (read by analyze.py)
.option post=1 post_version=2001 ingold=2
.include "/srv/auto/apps/asap7pdk/2022-fixed/asap7PDK_r1p7/models/hspice/7nm_TT_160803.pm"
************************************************************************
* auCdl Netlist:
*
* Library Name:  555-Neuron
* Top Cell Name: NEURON
* View Name:     schematic
* Netlisted on:  Nov 15 20:16:28 2026
************************************************************************

*.EQUATION
*.SCALE METER
*.MEGA

************************************************************************
* Library Name: 555-Neuron
* Cell Name:    NAND2
* View Name:    schematic
************************************************************************

.SUBCKT NAND2 A B VDD VSS Y
*.PININFO A:I B:I Y:O VDD:B VSS:B
MM0 Y A net35 VSS nmos_rvt w=108.00n l=20n nfin=4
MM1 net35 B VSS VSS nmos_rvt w=108.00n l=20n nfin=4
MM4 Y B VDD VDD pmos_rvt w=81.0n l=20n nfin=3
MM3 Y A VDD VDD pmos_rvt w=81.0n l=20n nfin=3
.ENDS

************************************************************************
* Library Name: 555-Neuron
* Cell Name:    OAI21
* View Name:    schematic
************************************************************************

.SUBCKT OAI21 A B C VDD VSS Y
*.PININFO A:I B:I C:I Y:O VDD:B VSS:B
MM2 net3 C VSS VSS nmos_rvt w=54.0n l=20n nfin=2
MM1 net3 B VSS VSS nmos_rvt w=54.0n l=20n nfin=2
MM0 Y A net3 VSS nmos_rvt w=54.0n l=20n nfin=2
MM5 Y B net17 VDD pmos_rvt w=81.0n l=20n nfin=3
MM4 net17 C VDD VDD pmos_rvt w=81.0n l=20n nfin=3
MM3 Y A VDD VDD pmos_rvt w=81.0n l=20n nfin=3
.ENDS

************************************************************************
* Library Name: 555-Neuron
* Cell Name:    FRONT
* View Name:    schematic
************************************************************************

.SUBCKT FRONT VDD VSS W0 W1 X0 X1 XN Z
*.PININFO W0:I W1:I X0:I X1:I XN:O Z:O VDD:B VSS:B
XI1 X0 W0 VDD VSS Z NAND2
XI0 X1 W1 VDD VSS net5 NAND2
XI2 net5 X1 W1 VDD VSS XN OAI21
.ENDS

************************************************************************
* Library Name: 555-Neuron
* Cell Name:    INV
* View Name:    schematic
************************************************************************

.SUBCKT INV IN OUT VDD VSS
*.PININFO IN:I OUT:O VDD:B VSS:B
MM0 OUT IN VSS VSS nmos_rvt w=54.0n l=20n nfin=2
MM1 OUT IN VDD VDD pmos_rvt w=81.0n l=20n nfin=3
.ENDS

************************************************************************
* Library Name: 555-Neuron
* Cell Name:    OAI221
* View Name:    schematic
************************************************************************

.SUBCKT OAI221 A B C D E VDD VSS Y
*.PININFO A:I B:I C:I D:I E:I Y:O VDD:B VSS:B
MM4 Y E VDD VDD pmos_rvt w=81.0n l=20n nfin=3
MM3 Y A net1 VDD pmos_rvt w=81.0n l=20n nfin=3
MM2 Y C net5 VDD pmos_rvt w=81.0n l=20n nfin=3
MM1 net5 D VDD VDD pmos_rvt w=81.0n l=20n nfin=3
MM0 net1 B VDD VDD pmos_rvt w=81.0n l=20n nfin=3
MM9 net23 D net27 VSS nmos_rvt w=54.0n l=20n nfin=2
MM8 Y B net23 VSS nmos_rvt w=54.0n l=20n nfin=2
MM7 net27 E VSS VSS nmos_rvt w=54.0n l=20n nfin=2
MM6 net23 C net27 VSS nmos_rvt w=54.0n l=20n nfin=2
MM5 Y A net23 VSS nmos_rvt w=54.0n l=20n nfin=2
.ENDS

************************************************************************
* Library Name: 555-Neuron
* Cell Name:    MAJI5M
* View Name:    schematic
************************************************************************

.SUBCKT MAJI5M A B C VDD VSS Y
*.PININFO A:I B:I C:I Y:O VDD:B VSS:B
MM8 Y C net3 VSS nmos_rvt w=54.0n l=20n nfin=2
MM5 Y A net40 VSS nmos_rvt w=54.0n l=20n nfin=2
MM9 net3 A VSS VSS nmos_rvt w=54.0n l=20n nfin=2
MM6 net40 B VSS VSS nmos_rvt w=54.0n l=20n nfin=2
MM7 net3 B VSS VSS nmos_rvt w=54.0n l=20n nfin=2
MM4 net42 B VDD VDD pmos_rvt w=81.0n l=20n nfin=3
MM1 net42 A VDD VDD pmos_rvt w=81.0n l=20n nfin=3
MM0 net43 B VDD VDD pmos_rvt w=81.0n l=20n nfin=3
MM3 Y A net43 VDD pmos_rvt w=81.0n l=20n nfin=3
MM2 Y C net42 VDD pmos_rvt w=81.0n l=20n nfin=3
.ENDS

************************************************************************
* Library Name: 555-Neuron
* Cell Name:    NCNT
* View Name:    schematic
************************************************************************

.SUBCKT NCNT B1 R1 R2 VDD VSS XNA XNB ZA ZB
*.PININFO B1:I XNA:I XNB:I ZA:I ZB:I R1:O R2:O VDD:B VSS:B
XI0 B1 net3 VDD VSS INV
XI1 XNA ZA XNB ZB net3 VDD VSS R1 OAI221
XI2 XNA net3 XNB VDD VSS R2 MAJI5M
.ENDS

************************************************************************
* Library Name: 555-Neuron
* Cell Name:    NAND3
* View Name:    schematic
************************************************************************

.SUBCKT NAND3 A B C VDD VSS Y
*.PININFO A:I B:I C:I Y:O VDD:B VSS:B
MM2 net7 C VSS VSS nmos_rvt w=54.0n l=20n nfin=2
MM1 net3 B net7 VSS nmos_rvt w=54.0n l=20n nfin=2
MM0 Y A net3 VSS nmos_rvt w=54.0n l=20n nfin=2
MM5 Y C VDD VDD pmos_rvt w=81.0n l=20n nfin=3
MM4 Y B VDD VDD pmos_rvt w=81.0n l=20n nfin=3
MM3 Y A VDD VDD pmos_rvt w=81.0n l=20n nfin=3
.ENDS

************************************************************************
* Library Name: 555-Neuron
* Cell Name:    NOR3
* View Name:    schematic
************************************************************************

.SUBCKT NOR3 A B C VDD VSS Y
*.PININFO A:I B:I C:I Y:O VDD:B VSS:B
MM2 Y A net5 VDD pmos_rvt w=162.00n l=20n nfin=6
MM1 net5 B net1 VDD pmos_rvt w=162.00n l=20n nfin=6
MM0 net1 C VDD VDD pmos_rvt w=162.00n l=20n nfin=6
MM5 Y C VSS VSS nmos_rvt w=54.0n l=20n nfin=2
MM4 Y B VSS VSS nmos_rvt w=54.0n l=20n nfin=2
MM3 Y A VSS VSS nmos_rvt w=54.0n l=20n nfin=2
.ENDS

************************************************************************
* Library Name: 555-Neuron
* Cell Name:    UCNT
* View Name:    schematic
************************************************************************

.SUBCKT UCNT B0 V1 V2 V3 VDD VSS ZA ZB
*.PININFO B0:I ZA:I ZB:I V1:O V2:O V3:O VDD:B VSS:B
XI0 B0 net3 VDD VSS INV
XI1 ZA ZB net3 VDD VSS V1 NAND3
XI2 ZA net3 ZB VDD VSS V2 MAJI5M
XI3 ZA ZB net3 VDD VSS V3 NOR3
.ENDS

************************************************************************
* Library Name: 555-Neuron
* Cell Name:    NOR
* View Name:    schematic
************************************************************************

.SUBCKT NOR A B VDD VSS Y
*.PININFO A:I B:I Y:O VDD:B VSS:B
MM2 Y B VSS VSS nmos_rvt w=54.0n l=20n nfin=2
MM0 Y A VSS VSS nmos_rvt w=54.0n l=20n nfin=2
MM3 Y B net5 VDD pmos_rvt w=162.00n l=20n nfin=6
MM1 net5 A VDD VDD pmos_rvt w=162.00n l=20n nfin=6
.ENDS

************************************************************************
* Library Name: 555-Neuron
* Cell Name:    OAI32
* View Name:    schematic
************************************************************************

.SUBCKT OAI32 A B C D E VDD VSS Y
*.PININFO A:I B:I C:I D:I E:I Y:O VDD:B VSS:B
MM8 net40 E VSS VSS nmos_rvt w=54.0n l=20n nfin=2
MM5 Y C net40 VSS nmos_rvt w=54.0n l=20n nfin=2
MM9 Y B net40 VSS nmos_rvt w=54.0n l=20n nfin=2
MM6 Y A net40 VSS nmos_rvt w=54.0n l=20n nfin=2
MM7 net40 D VSS VSS nmos_rvt w=54.0n l=20n nfin=2
MM4 Y A net9 VDD pmos_rvt w=81.0n l=20n nfin=3
MM1 net42 E VDD VDD pmos_rvt w=81.0n l=20n nfin=3
MM0 net39 C VDD VDD pmos_rvt w=81.0n l=20n nfin=3
MM3 net9 B net39 VDD pmos_rvt w=81.0n l=20n nfin=3
MM2 Y D net42 VDD pmos_rvt w=81.0n l=20n nfin=3
.ENDS

************************************************************************
* Library Name: 555-Neuron
* Cell Name:    OUT
* View Name:    schematic
************************************************************************

.SUBCKT OUT R1 R2 V1 V2 V3 VDD VSS Z0 Z1
*.PININFO R1:I R2:I V1:I V2:I V3:I Z0:O Z1:O VDD:B VSS:B
XI0 R1 net1 VDD VSS Z1 NOR
XI1 R1 net9 V2 R2 net6 VDD VSS Z0 OAI32
XI4 V3 net6 VDD VSS INV
XI3 V1 net9 VDD VSS INV
XI2 V2 net1 VDD VSS INV
.ENDS

************************************************************************
* Library Name: 555-Neuron
* Cell Name:    NEURON
* View Name:    schematic
************************************************************************

.SUBCKT NEURON B0 B1 VDD VSS WA0 WA1 WB0 WB1 XA0 XA1 XB0 XB1 Z0 Z1
*.PININFO B0:I B1:I WA0:I WA1:I WB0:I WB1:I XA0:I XA1:I XB0:I XB1:I Z0:O Z1:O
*.PININFO VDD:B VSS:B
XI1 VDD VSS WB0 WB1 XB0 XB1 net14 net13 FRONT
XI0 VDD VSS WA0 WA1 XA0 XA1 net6 net5 FRONT
XI2 B1 R1 R2 VDD VSS net6 net14 net5 net13 NCNT
XI3 B0 V1 V2 V3 VDD VSS net5 net13 UCNT
XI4 R1 R2 V1 V2 V3 VDD VSS Z0 Z1 OUT
.ENDS

vdd VDD 0 0.7
vss VSS 0 0
* ideal sources -> 2-stage INV drivers -> DUT pins
v_B0 src_B0 0 pwl(
+ 0.000000e+00 0 4.000000e-10 0 4.100000e-10 0.7 6.000000e-10 0.7 6.100000e-10 0 8.000000e-10 0
+ 8.100000e-10 0.7 1.000000e-09 0.7 1.010000e-09 0 4.400000e-09 0 4.410000e-09 0.7 4.600000e-09 0.7
+ 4.610000e-09 0 4.800000e-09 0 4.810000e-09 0.7 5.000000e-09 0.7 5.010000e-09 0 8.400000e-09 0
+ 8.410000e-09 0.7 8.600000e-09 0.7 8.610000e-09 0 8.800000e-09 0 8.810000e-09 0.7 9.000000e-09 0.7
+ 9.010000e-09 0 1.240000e-08 0 1.241000e-08 0.7 1.260000e-08 0.7 1.261000e-08 0 1.280000e-08 0
+ 1.281000e-08 0.7 1.300000e-08 0.7 1.301000e-08 0 1.640000e-08 0 1.641000e-08 0.7 1.660000e-08 0.7
+ 1.661000e-08 0 1.680000e-08 0 1.681000e-08 0.7 1.700000e-08 0.7 1.701000e-08 0 2.040000e-08 0
+ 2.041000e-08 0.7 2.060000e-08 0.7 2.061000e-08 0 2.080000e-08 0 2.081000e-08 0.7 2.100000e-08 0.7
+ 2.101000e-08 0 2.440000e-08 0 2.441000e-08 0.7 2.460000e-08 0.7 2.461000e-08 0 2.480000e-08 0
+ 2.481000e-08 0.7 2.500000e-08 0.7 2.501000e-08 0 2.840000e-08 0 2.841000e-08 0.7 2.860000e-08 0.7
+ 2.861000e-08 0 2.880000e-08 0 2.881000e-08 0.7 2.900000e-08 0.7 2.901000e-08 0 3.240000e-08 0
+ 3.241000e-08 0.7 3.260000e-08 0.7 3.261000e-08 0 3.280000e-08 0 3.281000e-08 0.7 3.300000e-08 0.7
+ 3.301000e-08 0 3.640000e-08 0 3.641000e-08 0.7 3.660000e-08 0.7 3.661000e-08 0 3.680000e-08 0
+ 3.681000e-08 0.7 3.700000e-08 0.7 3.701000e-08 0 4.040000e-08 0 4.041000e-08 0.7 4.060000e-08 0.7
+ 4.061000e-08 0 4.080000e-08 0 4.081000e-08 0.7 4.100000e-08 0.7 4.101000e-08 0 4.440000e-08 0
+ 4.441000e-08 0.7 4.460000e-08 0.7 4.461000e-08 0 4.480000e-08 0 4.481000e-08 0.7 4.500000e-08 0.7
+ 4.501000e-08 0 4.840000e-08 0 4.841000e-08 0.7 4.860000e-08 0.7 4.861000e-08 0 4.880000e-08 0
+ 4.881000e-08 0.7 4.900000e-08 0.7 4.901000e-08 0 5.240000e-08 0 5.241000e-08 0.7 5.260000e-08 0.7
+ 5.261000e-08 0 5.280000e-08 0 5.281000e-08 0.7 5.300000e-08 0.7 5.301000e-08 0 5.640000e-08 0
+ 5.641000e-08 0.7 5.660000e-08 0.7 5.661000e-08 0 5.680000e-08 0 5.681000e-08 0.7 5.700000e-08 0.7
+ 5.701000e-08 0 6.040000e-08 0 6.041000e-08 0.7 6.060000e-08 0.7 6.061000e-08 0 6.080000e-08 0
+ 6.081000e-08 0.7 6.100000e-08 0.7 6.101000e-08 0 6.440000e-08 0 6.441000e-08 0.7 6.460000e-08 0.7
+ 6.461000e-08 0 6.480000e-08 0 6.481000e-08 0.7 6.500000e-08 0.7 6.501000e-08 0 6.840000e-08 0
+ 6.841000e-08 0.7 6.860000e-08 0.7 6.861000e-08 0 6.880000e-08 0 6.881000e-08 0.7 6.900000e-08 0.7
+ 6.901000e-08 0 7.240000e-08 0 7.241000e-08 0.7 7.260000e-08 0.7 7.261000e-08 0 7.280000e-08 0
+ 7.281000e-08 0.7 7.300000e-08 0.7 7.301000e-08 0 7.640000e-08 0 7.641000e-08 0.7 7.660000e-08 0.7
+ 7.661000e-08 0 7.680000e-08 0 7.681000e-08 0.7 7.700000e-08 0.7 7.701000e-08 0 8.040000e-08 0
+ 8.041000e-08 0.7 8.060000e-08 0.7 8.061000e-08 0 8.080000e-08 0 8.081000e-08 0.7 8.100000e-08 0.7
+ 8.101000e-08 0 8.440000e-08 0 8.441000e-08 0.7 8.460000e-08 0.7 8.461000e-08 0 8.480000e-08 0
+ 8.481000e-08 0.7 8.500000e-08 0.7 8.501000e-08 0 8.840000e-08 0 8.841000e-08 0.7 8.860000e-08 0.7
+ 8.861000e-08 0 8.880000e-08 0 8.881000e-08 0.7 8.900000e-08 0.7 8.901000e-08 0 9.240000e-08 0
+ 9.241000e-08 0.7 9.260000e-08 0.7 9.261000e-08 0 9.280000e-08 0 9.281000e-08 0.7 9.300000e-08 0.7
+ 9.301000e-08 0 9.640000e-08 0 9.641000e-08 0.7 9.660000e-08 0.7 9.661000e-08 0 9.680000e-08 0
+ 9.681000e-08 0.7 9.700000e-08 0.7 9.701000e-08 0 1.004000e-07 0 1.004100e-07 0.7 1.006000e-07 0.7
+ 1.006100e-07 0 1.008000e-07 0 1.008100e-07 0.7 1.010000e-07 0.7 1.010100e-07 0 1.044000e-07 0
+ 1.044100e-07 0.7 1.046000e-07 0.7 1.046100e-07 0 1.048000e-07 0 1.048100e-07 0.7 1.050000e-07 0.7
+ 1.050100e-07 0 1.084000e-07 0 1.084100e-07 0.7 1.086000e-07 0.7 1.086100e-07 0 1.088000e-07 0
+ 1.088100e-07 0.7 1.090000e-07 0.7 1.090100e-07 0 1.124000e-07 0 1.124100e-07 0.7 1.126000e-07 0.7
+ 1.126100e-07 0 1.128000e-07 0 1.128100e-07 0.7 1.130000e-07 0.7 1.130100e-07 0 1.164000e-07 0
+ 1.164100e-07 0.7 1.166000e-07 0.7 1.166100e-07 0 1.168000e-07 0 1.168100e-07 0.7 1.170000e-07 0.7
+ 1.170100e-07 0 1.204000e-07 0 1.204100e-07 0.7 1.206000e-07 0.7 1.206100e-07 0 1.208000e-07 0
+ 1.208100e-07 0.7 1.210000e-07 0.7 1.210100e-07 0 1.244000e-07 0 1.244100e-07 0.7 1.246000e-07 0.7
+ 1.246100e-07 0 1.248000e-07 0 1.248100e-07 0.7 1.250000e-07 0.7 1.250100e-07 0 1.284000e-07 0
+ 1.284100e-07 0.7 1.286000e-07 0.7 1.286100e-07 0 1.288000e-07 0 1.288100e-07 0.7 1.290000e-07 0.7
+ 1.290100e-07 0 1.324000e-07 0 1.324100e-07 0.7 1.326000e-07 0.7 1.326100e-07 0 1.328000e-07 0
+ 1.328100e-07 0.7 1.330000e-07 0.7 1.330100e-07 0 1.364000e-07 0 1.364100e-07 0.7 1.366000e-07 0.7
+ 1.366100e-07 0 1.368000e-07 0 1.368100e-07 0.7 1.370000e-07 0.7 1.370100e-07 0 1.404000e-07 0
+ 1.404100e-07 0.7 1.406000e-07 0.7 1.406100e-07 0 1.408000e-07 0 1.408100e-07 0.7 1.410000e-07 0.7
+ 1.410100e-07 0 1.444000e-07 0 1.444100e-07 0.7 1.446000e-07 0.7 1.446100e-07 0 1.448000e-07 0
+ 1.448100e-07 0.7 1.450000e-07 0.7 1.450100e-07 0 1.484000e-07 0 1.484100e-07 0.7 1.486000e-07 0.7
+ 1.486100e-07 0 1.488000e-07 0 1.488100e-07 0.7 1.490000e-07 0.7 1.490100e-07 0 1.524000e-07 0
+ 1.524100e-07 0.7 1.526000e-07 0.7 1.526100e-07 0 1.528000e-07 0 1.528100e-07 0.7 1.530000e-07 0.7
+ 1.530100e-07 0 1.564000e-07 0 1.564100e-07 0.7 1.566000e-07 0.7 1.566100e-07 0 1.568000e-07 0
+ 1.568100e-07 0.7 1.570000e-07 0.7 1.570100e-07 0 1.604000e-07 0 1.604100e-07 0.7 1.606000e-07 0.7
+ 1.606100e-07 0 1.608000e-07 0 1.608100e-07 0.7 1.610000e-07 0.7 1.610100e-07 0 1.644000e-07 0
+ 1.644100e-07 0.7 1.646000e-07 0.7 1.646100e-07 0 1.648000e-07 0 1.648100e-07 0.7 1.650000e-07 0.7
+ 1.650100e-07 0 1.684000e-07 0 1.684100e-07 0.7 1.686000e-07 0.7 1.686100e-07 0 1.688000e-07 0
+ 1.688100e-07 0.7 1.690000e-07 0.7 1.690100e-07 0 1.724000e-07 0 1.724100e-07 0.7 1.726000e-07 0.7
+ 1.726100e-07 0 1.728000e-07 0 1.728100e-07 0.7 1.730000e-07 0.7 1.730100e-07 0 1.764000e-07 0
+ 1.764100e-07 0.7 1.766000e-07 0.7 1.766100e-07 0 1.768000e-07 0 1.768100e-07 0.7 1.770000e-07 0.7
+ 1.770100e-07 0 1.804000e-07 0 1.804100e-07 0.7 1.806000e-07 0.7 1.806100e-07 0 1.808000e-07 0
+ 1.808100e-07 0.7 1.810000e-07 0.7 1.810100e-07 0 1.844000e-07 0 1.844100e-07 0.7 1.846000e-07 0.7
+ 1.846100e-07 0 1.848000e-07 0 1.848100e-07 0.7 1.850000e-07 0.7 1.850100e-07 0 1.884000e-07 0
+ 1.884100e-07 0.7 1.886000e-07 0.7 1.886100e-07 0 1.888000e-07 0 1.888100e-07 0.7 1.890000e-07 0.7
+ 1.890100e-07 0 1.924000e-07 0 1.924100e-07 0.7 1.926000e-07 0.7 1.926100e-07 0 1.928000e-07 0
+ 1.928100e-07 0.7 1.930000e-07 0.7 1.930100e-07 0 1.964000e-07 0 1.964100e-07 0.7 1.966000e-07 0.7
+ 1.966100e-07 0 1.968000e-07 0 1.968100e-07 0.7 1.970000e-07 0.7 1.970100e-07 0 2.004000e-07 0
+ 2.004100e-07 0.7 2.006000e-07 0.7 2.006100e-07 0 2.008000e-07 0 2.008100e-07 0.7 2.010000e-07 0.7
+ 2.010100e-07 0 2.044000e-07 0 2.044100e-07 0.7 2.046000e-07 0.7 2.046100e-07 0 2.048000e-07 0
+ 2.048100e-07 0.7 2.050000e-07 0.7 2.050100e-07 0 2.084000e-07 0 2.084100e-07 0.7 2.086000e-07 0.7
+ 2.086100e-07 0 2.088000e-07 0 2.088100e-07 0.7 2.090000e-07 0.7 2.090100e-07 0 2.124000e-07 0
+ 2.124100e-07 0.7 2.126000e-07 0.7 2.126100e-07 0 2.128000e-07 0 2.128100e-07 0.7 2.130000e-07 0.7
+ 2.130100e-07 0 2.164000e-07 0 2.164100e-07 0.7 2.166000e-07 0.7 2.166100e-07 0 2.168000e-07 0
+ 2.168100e-07 0.7 2.170000e-07 0.7 2.170100e-07 0 2.204000e-07 0 2.204100e-07 0.7 2.206000e-07 0.7
+ 2.206100e-07 0 2.208000e-07 0 2.208100e-07 0.7 2.210000e-07 0.7 2.210100e-07 0 2.244000e-07 0
+ 2.244100e-07 0.7 2.246000e-07 0.7 2.246100e-07 0 2.248000e-07 0 2.248100e-07 0.7 2.250000e-07 0.7
+ 2.250100e-07 0 2.284000e-07 0 2.284100e-07 0.7 2.286000e-07 0.7 2.286100e-07 0 2.288000e-07 0
+ 2.288100e-07 0.7 2.290000e-07 0.7 2.290100e-07 0 2.324000e-07 0 2.324100e-07 0.7 2.326000e-07 0.7
+ 2.326100e-07 0 2.328000e-07 0 2.328100e-07 0.7 2.330000e-07 0.7 2.330100e-07 0 2.364000e-07 0
+ 2.364100e-07 0.7 2.366000e-07 0.7 2.366100e-07 0 2.368000e-07 0 2.368100e-07 0.7 2.370000e-07 0.7
+ 2.370100e-07 0 2.404000e-07 0 2.404100e-07 0.7 2.406000e-07 0.7 2.406100e-07 0 2.408000e-07 0
+ 2.408100e-07 0.7 2.410000e-07 0.7 2.410100e-07 0 2.444000e-07 0 2.444100e-07 0.7 2.446000e-07 0.7
+ 2.446100e-07 0 2.448000e-07 0 2.448100e-07 0.7 2.450000e-07 0.7 2.450100e-07 0 2.484000e-07 0
+ 2.484100e-07 0.7 2.486000e-07 0.7 2.486100e-07 0 2.488000e-07 0 2.488100e-07 0.7 2.490000e-07 0.7
+ 2.490100e-07 0 2.524000e-07 0 2.524100e-07 0.7 2.526000e-07 0.7 2.526100e-07 0 2.528000e-07 0
+ 2.528100e-07 0.7 2.530000e-07 0.7 2.530100e-07 0 2.564000e-07 0 2.564100e-07 0.7 2.566000e-07 0.7
+ 2.566100e-07 0 2.568000e-07 0 2.568100e-07 0.7 2.570000e-07 0.7 2.570100e-07 0 2.604000e-07 0
+ 2.604100e-07 0.7 2.606000e-07 0.7 2.606100e-07 0 2.608000e-07 0 2.608100e-07 0.7 2.610000e-07 0.7
+ 2.610100e-07 0 2.644000e-07 0 2.644100e-07 0.7 2.646000e-07 0.7 2.646100e-07 0 2.648000e-07 0
+ 2.648100e-07 0.7 2.650000e-07 0.7 2.650100e-07 0 2.684000e-07 0 2.684100e-07 0.7 2.686000e-07 0.7
+ 2.686100e-07 0 2.688000e-07 0 2.688100e-07 0.7 2.690000e-07 0.7 2.690100e-07 0 2.724000e-07 0
+ 2.724100e-07 0.7 2.726000e-07 0.7 2.726100e-07 0 2.728000e-07 0 2.728100e-07 0.7 2.730000e-07 0.7
+ 2.730100e-07 0 2.764000e-07 0 2.764100e-07 0.7 2.766000e-07 0.7 2.766100e-07 0 2.768000e-07 0
+ 2.768100e-07 0.7 2.770000e-07 0.7 2.770100e-07 0 2.804000e-07 0 2.804100e-07 0.7 2.806000e-07 0.7
+ 2.806100e-07 0 2.808000e-07 0 2.808100e-07 0.7 2.810000e-07 0.7 2.810100e-07 0 2.844000e-07 0
+ 2.844100e-07 0.7 2.846000e-07 0.7 2.846100e-07 0 2.848000e-07 0 2.848100e-07 0.7 2.850000e-07 0.7
+ 2.850100e-07 0 2.884000e-07 0 2.884100e-07 0.7 2.886000e-07 0.7 2.886100e-07 0 2.888000e-07 0
+ 2.888100e-07 0.7 2.890000e-07 0.7 2.890100e-07 0 2.924000e-07 0 2.924100e-07 0.7 2.926000e-07 0.7
+ 2.926100e-07 0 2.928000e-07 0 2.928100e-07 0.7 2.930000e-07 0.7 2.930100e-07 0 2.964000e-07 0
+ 2.964100e-07 0.7 2.966000e-07 0.7 2.966100e-07 0 2.968000e-07 0 2.968100e-07 0.7 2.970000e-07 0.7
+ 2.970100e-07 0 3.004000e-07 0 3.004100e-07 0.7 3.006000e-07 0.7 3.006100e-07 0 3.008000e-07 0
+ 3.008100e-07 0.7 3.010000e-07 0.7 3.010100e-07 0 3.044000e-07 0 3.044100e-07 0.7 3.046000e-07 0.7
+ 3.046100e-07 0 3.048000e-07 0 3.048100e-07 0.7 3.050000e-07 0.7 3.050100e-07 0 3.084000e-07 0
+ 3.084100e-07 0.7 3.086000e-07 0.7 3.086100e-07 0 3.088000e-07 0 3.088100e-07 0.7 3.090000e-07 0.7
+ 3.090100e-07 0 3.124000e-07 0 3.124100e-07 0.7 3.126000e-07 0.7 3.126100e-07 0 3.128000e-07 0
+ 3.128100e-07 0.7 3.130000e-07 0.7 3.130100e-07 0 3.164000e-07 0 3.164100e-07 0.7 3.166000e-07 0.7
+ 3.166100e-07 0 3.168000e-07 0 3.168100e-07 0.7 3.170000e-07 0.7 3.170100e-07 0 3.204000e-07 0
+ 3.204100e-07 0.7 3.206000e-07 0.7 3.206100e-07 0 3.208000e-07 0 3.208100e-07 0.7 3.210000e-07 0.7
+ 3.210100e-07 0 3.242000e-07 0 3.242100e-07 0.7 3.244000e-07 0.7 3.244100e-07 0 3.246000e-07 0
+ 3.246100e-07 0.7 3.284000e-07 0.7 3.284100e-07 0 3.286000e-07 0 3.286100e-07 0.7 3.324000e-07 0.7
+ 3.324100e-07 0 3.326000e-07 0 3.326100e-07 0.7 3.364000e-07 0.7 3.364100e-07 0 3.366000e-07 0
+ 3.366100e-07 0.7 3.404000e-07 0.7 3.404100e-07 0 3.406000e-07 0 3.406100e-07 0.7 3.444000e-07 0.7
+ 3.444100e-07 0 3.446000e-07 0 3.446100e-07 0.7 3.484000e-07 0.7 3.484100e-07 0 3.486000e-07 0
+ 3.486100e-07 0.7 3.524000e-07 0.7 3.524100e-07 0 3.526000e-07 0 3.526100e-07 0.7 3.564000e-07 0.7
+ 3.564100e-07 0 3.566000e-07 0 3.566100e-07 0.7 3.604000e-07 0.7 3.604100e-07 0 3.606000e-07 0
+ 3.606100e-07 0.7 3.644000e-07 0.7 3.644100e-07 0 3.646000e-07 0 3.646100e-07 0.7 3.684000e-07 0.7
+ 3.684100e-07 0 3.686000e-07 0 3.686100e-07 0.7 3.724000e-07 0.7 3.724100e-07 0 3.726000e-07 0
+ 3.726100e-07 0.7 3.764000e-07 0.7 3.764100e-07 0 3.766000e-07 0 3.766100e-07 0.7 3.804000e-07 0.7
+ 3.804100e-07 0 3.806000e-07 0 3.806100e-07 0.7 3.844000e-07 0.7 3.844100e-07 0 3.846000e-07 0
+ 3.846100e-07 0.7 3.884000e-07 0.7 3.884100e-07 0 3.886000e-07 0 3.886100e-07 0.7 3.924000e-07 0.7
+ 3.924100e-07 0 3.926000e-07 0 3.926100e-07 0.7 3.964000e-07 0.7 3.964100e-07 0 3.966000e-07 0
+ 3.966100e-07 0.7 4.004000e-07 0.7 4.004100e-07 0 4.006000e-07 0 4.006100e-07 0.7 4.044000e-07 0.7
+ 4.044100e-07 0 4.046000e-07 0 4.046100e-07 0.7 4.084000e-07 0.7 4.084100e-07 0 4.086000e-07 0
+ 4.086100e-07 0.7 4.124000e-07 0.7 4.124100e-07 0 4.126000e-07 0 4.126100e-07 0.7 4.164000e-07 0.7
+ 4.164100e-07 0 4.166000e-07 0 4.166100e-07 0.7 4.204000e-07 0.7 4.204100e-07 0 4.206000e-07 0
+ 4.206100e-07 0.7 4.244000e-07 0.7 4.244100e-07 0 4.246000e-07 0 4.246100e-07 0.7 4.284000e-07 0.7
+ 4.284100e-07 0 4.286000e-07 0 4.286100e-07 0.7 4.324000e-07 0.7 4.324100e-07 0 4.326000e-07 0
+ 4.326100e-07 0.7 4.364000e-07 0.7 4.364100e-07 0 4.366000e-07 0 4.366100e-07 0.7 4.404000e-07 0.7
+ 4.404100e-07 0 4.406000e-07 0 4.406100e-07 0.7 4.444000e-07 0.7 4.444100e-07 0 4.446000e-07 0
+ 4.446100e-07 0.7 4.484000e-07 0.7 4.484100e-07 0 4.486000e-07 0 4.486100e-07 0.7 4.524000e-07 0.7
+ 4.524100e-07 0 4.526000e-07 0 4.526100e-07 0.7 4.564000e-07 0.7 4.564100e-07 0 4.566000e-07 0
+ 4.566100e-07 0.7 4.604000e-07 0.7 4.604100e-07 0 4.606000e-07 0 4.606100e-07 0.7 4.644000e-07 0.7
+ 4.644100e-07 0 4.646000e-07 0 4.646100e-07 0.7 4.684000e-07 0.7 4.684100e-07 0 4.686000e-07 0
+ 4.686100e-07 0.7 4.724000e-07 0.7 4.724100e-07 0 4.726000e-07 0 4.726100e-07 0.7 4.764000e-07 0.7
+ 4.764100e-07 0 4.766000e-07 0 4.766100e-07 0.7 4.804000e-07 0.7 4.804100e-07 0 4.806000e-07 0
+ 4.806100e-07 0.7 4.844000e-07 0.7 4.844100e-07 0 4.846000e-07 0 4.846100e-07 0.7 4.884000e-07 0.7
+ 4.884100e-07 0 4.886000e-07 0 4.886100e-07 0.7 4.924000e-07 0.7 4.924100e-07 0 4.926000e-07 0
+ 4.926100e-07 0.7 4.964000e-07 0.7 4.964100e-07 0 4.966000e-07 0 4.966100e-07 0.7 5.004000e-07 0.7
+ 5.004100e-07 0 5.006000e-07 0 5.006100e-07 0.7 5.044000e-07 0.7 5.044100e-07 0 5.046000e-07 0
+ 5.046100e-07 0.7 5.084000e-07 0.7 5.084100e-07 0 5.086000e-07 0 5.086100e-07 0.7 5.124000e-07 0.7
+ 5.124100e-07 0 5.126000e-07 0 5.126100e-07 0.7 5.164000e-07 0.7 5.164100e-07 0 5.166000e-07 0
+ 5.166100e-07 0.7 5.204000e-07 0.7 5.204100e-07 0 5.206000e-07 0 5.206100e-07 0.7 5.244000e-07 0.7
+ 5.244100e-07 0 5.246000e-07 0 5.246100e-07 0.7 5.284000e-07 0.7 5.284100e-07 0 5.286000e-07 0
+ 5.286100e-07 0.7 5.324000e-07 0.7 5.324100e-07 0 5.326000e-07 0 5.326100e-07 0.7 5.364000e-07 0.7
+ 5.364100e-07 0 5.366000e-07 0 5.366100e-07 0.7 5.404000e-07 0.7 5.404100e-07 0 5.406000e-07 0
+ 5.406100e-07 0.7 5.444000e-07 0.7 5.444100e-07 0 5.446000e-07 0 5.446100e-07 0.7 5.484000e-07 0.7
+ 5.484100e-07 0 5.486000e-07 0 5.486100e-07 0.7 5.524000e-07 0.7 5.524100e-07 0 5.526000e-07 0
+ 5.526100e-07 0.7 5.564000e-07 0.7 5.564100e-07 0 5.566000e-07 0 5.566100e-07 0.7 5.604000e-07 0.7
+ 5.604100e-07 0 5.606000e-07 0 5.606100e-07 0.7 5.644000e-07 0.7 5.644100e-07 0 5.646000e-07 0
+ 5.646100e-07 0.7 5.684000e-07 0.7 5.684100e-07 0 5.686000e-07 0 5.686100e-07 0.7 5.724000e-07 0.7
+ 5.724100e-07 0 5.726000e-07 0 5.726100e-07 0.7 5.764000e-07 0.7 5.764100e-07 0 5.766000e-07 0
+ 5.766100e-07 0.7 5.804000e-07 0.7 5.804100e-07 0 5.806000e-07 0 5.806100e-07 0.7 5.844000e-07 0.7
+ 5.844100e-07 0 5.846000e-07 0 5.846100e-07 0.7 5.884000e-07 0.7 5.884100e-07 0 5.886000e-07 0
+ 5.886100e-07 0.7 5.924000e-07 0.7 5.924100e-07 0 5.926000e-07 0 5.926100e-07 0.7 5.964000e-07 0.7
+ 5.964100e-07 0 5.966000e-07 0 5.966100e-07 0.7 6.004000e-07 0.7 6.004100e-07 0 6.006000e-07 0
+ 6.006100e-07 0.7 6.044000e-07 0.7 6.044100e-07 0 6.046000e-07 0 6.046100e-07 0.7 6.084000e-07 0.7
+ 6.084100e-07 0 6.086000e-07 0 6.086100e-07 0.7 6.124000e-07 0.7 6.124100e-07 0 6.126000e-07 0
+ 6.126100e-07 0.7 6.164000e-07 0.7 6.164100e-07 0 6.166000e-07 0 6.166100e-07 0.7 6.204000e-07 0.7
+ 6.204100e-07 0 6.206000e-07 0 6.206100e-07 0.7 6.244000e-07 0.7 6.244100e-07 0 6.246000e-07 0
+ 6.246100e-07 0.7 6.284000e-07 0.7 6.284100e-07 0 6.286000e-07 0 6.286100e-07 0.7 6.324000e-07 0.7
+ 6.324100e-07 0 6.326000e-07 0 6.326100e-07 0.7 6.364000e-07 0.7 6.364100e-07 0 6.366000e-07 0
+ 6.366100e-07 0.7 6.404000e-07 0.7 6.404100e-07 0 6.406000e-07 0 6.406100e-07 0.7 6.444000e-07 0.7
+ 6.444100e-07 0 6.446000e-07 0 6.446100e-07 0.7 6.484000e-07 0.7 6.484100e-07 0 6.486000e-07 0
+ 6.486100e-07 0.7 6.524000e-07 0.7 6.524100e-07 0 6.526000e-07 0 6.526100e-07 0.7 6.564000e-07 0.7
+ 6.564100e-07 0 6.566000e-07 0 6.566100e-07 0.7 6.604000e-07 0.7 6.604100e-07 0 6.606000e-07 0
+ 6.606100e-07 0.7 6.644000e-07 0.7 6.644100e-07 0 6.646000e-07 0 6.646100e-07 0.7 6.684000e-07 0.7
+ 6.684100e-07 0 6.686000e-07 0 6.686100e-07 0.7 6.724000e-07 0.7 6.724100e-07 0 6.726000e-07 0
+ 6.726100e-07 0.7 6.764000e-07 0.7 6.764100e-07 0 6.766000e-07 0 6.766100e-07 0.7 6.804000e-07 0.7
+ 6.804100e-07 0 6.806000e-07 0 6.806100e-07 0.7 6.844000e-07 0.7 6.844100e-07 0 6.846000e-07 0
+ 6.846100e-07 0.7 6.884000e-07 0.7 6.884100e-07 0 6.886000e-07 0 6.886100e-07 0.7 6.924000e-07 0.7
+ 6.924100e-07 0 6.926000e-07 0 6.926100e-07 0.7 6.964000e-07 0.7 6.964100e-07 0 6.966000e-07 0
+ 6.966100e-07 0.7 7.004000e-07 0.7 7.004100e-07 0 7.006000e-07 0 7.006100e-07 0.7 7.044000e-07 0.7
+ 7.044100e-07 0 7.046000e-07 0 7.046100e-07 0.7 7.084000e-07 0.7 7.084100e-07 0 7.086000e-07 0
+ 7.086100e-07 0.7 7.124000e-07 0.7 7.124100e-07 0 7.126000e-07 0 7.126100e-07 0.7 7.164000e-07 0.7
+ 7.164100e-07 0 7.166000e-07 0 7.166100e-07 0.7 7.204000e-07 0.7 7.204100e-07 0 7.206000e-07 0
+ 7.206100e-07 0.7 7.244000e-07 0.7 7.244100e-07 0 7.246000e-07 0 7.246100e-07 0.7 7.284000e-07 0.7
+ 7.284100e-07 0 7.286000e-07 0 7.286100e-07 0.7 7.324000e-07 0.7 7.324100e-07 0 7.326000e-07 0
+ 7.326100e-07 0.7 7.364000e-07 0.7 7.364100e-07 0 7.366000e-07 0 7.366100e-07 0.7 7.404000e-07 0.7
+ 7.404100e-07 0 7.406000e-07 0 7.406100e-07 0.7 7.444000e-07 0.7 7.444100e-07 0 7.446000e-07 0
+ 7.446100e-07 0.7 7.484000e-07 0.7 7.484100e-07 0 7.486000e-07 0 7.486100e-07 0.7 7.524000e-07 0.7
+ 7.524100e-07 0 7.526000e-07 0 7.526100e-07 0.7 7.564000e-07 0.7 7.564100e-07 0 7.566000e-07 0
+ 7.566100e-07 0.7 7.604000e-07 0.7 7.604100e-07 0 7.606000e-07 0 7.606100e-07 0.7 7.644000e-07 0.7
+ 7.644100e-07 0 7.646000e-07 0 7.646100e-07 0.7 7.684000e-07 0.7 7.684100e-07 0 7.686000e-07 0
+ 7.686100e-07 0.7 7.724000e-07 0.7 7.724100e-07 0 7.726000e-07 0 7.726100e-07 0.7 7.764000e-07 0.7
+ 7.764100e-07 0 7.766000e-07 0 7.766100e-07 0.7 7.804000e-07 0.7 7.804100e-07 0 7.806000e-07 0
+ 7.806100e-07 0.7 7.844000e-07 0.7 7.844100e-07 0 7.846000e-07 0 7.846100e-07 0.7 7.884000e-07 0.7
+ 7.884100e-07 0 7.886000e-07 0 7.886100e-07 0.7 7.924000e-07 0.7 7.924100e-07 0 7.926000e-07 0
+ 7.926100e-07 0.7 7.964000e-07 0.7 7.964100e-07 0 7.966000e-07 0 7.966100e-07 0.7 8.004000e-07 0.7
+ 8.004100e-07 0 8.006000e-07 0 8.006100e-07 0.7 8.044000e-07 0.7 8.044100e-07 0 8.046000e-07 0
+ 8.046100e-07 0.7 8.084000e-07 0.7 8.084100e-07 0 8.086000e-07 0 8.086100e-07 0.7 8.124000e-07 0.7
+ 8.124100e-07 0 8.126000e-07 0 8.126100e-07 0.7 8.164000e-07 0.7 8.164100e-07 0 8.166000e-07 0
+ 8.166100e-07 0.7 8.204000e-07 0.7 8.204100e-07 0 8.206000e-07 0 8.206100e-07 0.7 8.244000e-07 0.7
+ 8.244100e-07 0 8.246000e-07 0 8.246100e-07 0.7 8.284000e-07 0.7 8.284100e-07 0 8.286000e-07 0
+ 8.286100e-07 0.7 8.324000e-07 0.7 8.324100e-07 0 8.326000e-07 0 8.326100e-07 0.7 8.364000e-07 0.7
+ 8.364100e-07 0 8.366000e-07 0 8.366100e-07 0.7 8.404000e-07 0.7 8.404100e-07 0 8.406000e-07 0
+ 8.406100e-07 0.7 8.444000e-07 0.7 8.444100e-07 0 8.446000e-07 0 8.446100e-07 0.7 8.484000e-07 0.7
+ 8.484100e-07 0 8.486000e-07 0 8.486100e-07 0.7 8.524000e-07 0.7 8.524100e-07 0 8.526000e-07 0
+ 8.526100e-07 0.7 8.564000e-07 0.7 8.564100e-07 0 8.566000e-07 0 8.566100e-07 0.7 8.604000e-07 0.7
+ 8.604100e-07 0 8.606000e-07 0 8.606100e-07 0.7 8.644000e-07 0.7 8.644100e-07 0 8.646000e-07 0
+ 8.646100e-07 0.7 8.684000e-07 0.7 8.684100e-07 0 8.686000e-07 0 8.686100e-07 0.7 8.724000e-07 0.7
+ 8.724100e-07 0 8.726000e-07 0 8.726100e-07 0.7 8.764000e-07 0.7 8.764100e-07 0 8.766000e-07 0
+ 8.766100e-07 0.7 8.804000e-07 0.7 8.804100e-07 0 8.806000e-07 0 8.806100e-07 0.7 8.844000e-07 0.7
+ 8.844100e-07 0 8.846000e-07 0 8.846100e-07 0.7 8.884000e-07 0.7 8.884100e-07 0 8.886000e-07 0
+ 8.886100e-07 0.7 8.924000e-07 0.7 8.924100e-07 0 8.926000e-07 0 8.926100e-07 0.7 8.964000e-07 0.7
+ 8.964100e-07 0 8.966000e-07 0 8.966100e-07 0.7 9.004000e-07 0.7 9.004100e-07 0 9.006000e-07 0
+ 9.006100e-07 0.7 9.044000e-07 0.7 9.044100e-07 0 9.046000e-07 0 9.046100e-07 0.7 9.084000e-07 0.7
+ 9.084100e-07 0 9.086000e-07 0 9.086100e-07 0.7 9.124000e-07 0.7 9.124100e-07 0 9.126000e-07 0
+ 9.126100e-07 0.7 9.164000e-07 0.7 9.164100e-07 0 9.166000e-07 0 9.166100e-07 0.7 9.204000e-07 0.7
+ 9.204100e-07 0 9.206000e-07 0 9.206100e-07 0.7 9.244000e-07 0.7 9.244100e-07 0 9.246000e-07 0
+ 9.246100e-07 0.7 9.284000e-07 0.7 9.284100e-07 0 9.286000e-07 0 9.286100e-07 0.7 9.324000e-07 0.7
+ 9.324100e-07 0 9.326000e-07 0 9.326100e-07 0.7 9.364000e-07 0.7 9.364100e-07 0 9.366000e-07 0
+ 9.366100e-07 0.7 9.404000e-07 0.7 9.404100e-07 0 9.406000e-07 0 9.406100e-07 0.7 9.444000e-07 0.7
+ 9.444100e-07 0 9.446000e-07 0 9.446100e-07 0.7 9.484000e-07 0.7 9.484100e-07 0 9.486000e-07 0
+ 9.486100e-07 0.7 9.524000e-07 0.7 9.524100e-07 0 9.526000e-07 0 9.526100e-07 0.7 9.564000e-07 0.7
+ 9.564100e-07 0 9.566000e-07 0 9.566100e-07 0.7 9.604000e-07 0.7 9.604100e-07 0 9.606000e-07 0
+ 9.606100e-07 0.7 9.644000e-07 0.7 9.644100e-07 0 9.646000e-07 0 9.646100e-07 0.7 9.684000e-07 0.7
+ 9.684100e-07 0 9.686000e-07 0 9.686100e-07 0.7 )
v_B1 src_B1 0 pwl(
+ 0.000000e+00 0 8.000000e-10 0 8.100000e-10 0.7 1.000000e-09 0.7 1.010000e-09 0 4.800000e-09 0
+ 4.810000e-09 0.7 5.000000e-09 0.7 5.010000e-09 0 8.800000e-09 0 8.810000e-09 0.7 9.000000e-09 0.7
+ 9.010000e-09 0 1.280000e-08 0 1.281000e-08 0.7 1.300000e-08 0.7 1.301000e-08 0 1.680000e-08 0
+ 1.681000e-08 0.7 1.700000e-08 0.7 1.701000e-08 0 2.080000e-08 0 2.081000e-08 0.7 2.100000e-08 0.7
+ 2.101000e-08 0 2.480000e-08 0 2.481000e-08 0.7 2.500000e-08 0.7 2.501000e-08 0 2.880000e-08 0
+ 2.881000e-08 0.7 2.900000e-08 0.7 2.901000e-08 0 3.280000e-08 0 3.281000e-08 0.7 3.300000e-08 0.7
+ 3.301000e-08 0 3.680000e-08 0 3.681000e-08 0.7 3.700000e-08 0.7 3.701000e-08 0 4.080000e-08 0
+ 4.081000e-08 0.7 4.100000e-08 0.7 4.101000e-08 0 4.480000e-08 0 4.481000e-08 0.7 4.500000e-08 0.7
+ 4.501000e-08 0 4.880000e-08 0 4.881000e-08 0.7 4.900000e-08 0.7 4.901000e-08 0 5.280000e-08 0
+ 5.281000e-08 0.7 5.300000e-08 0.7 5.301000e-08 0 5.680000e-08 0 5.681000e-08 0.7 5.700000e-08 0.7
+ 5.701000e-08 0 6.080000e-08 0 6.081000e-08 0.7 6.100000e-08 0.7 6.101000e-08 0 6.480000e-08 0
+ 6.481000e-08 0.7 6.500000e-08 0.7 6.501000e-08 0 6.880000e-08 0 6.881000e-08 0.7 6.900000e-08 0.7
+ 6.901000e-08 0 7.280000e-08 0 7.281000e-08 0.7 7.300000e-08 0.7 7.301000e-08 0 7.680000e-08 0
+ 7.681000e-08 0.7 7.700000e-08 0.7 7.701000e-08 0 8.080000e-08 0 8.081000e-08 0.7 8.100000e-08 0.7
+ 8.101000e-08 0 8.480000e-08 0 8.481000e-08 0.7 8.500000e-08 0.7 8.501000e-08 0 8.880000e-08 0
+ 8.881000e-08 0.7 8.900000e-08 0.7 8.901000e-08 0 9.280000e-08 0 9.281000e-08 0.7 9.300000e-08 0.7
+ 9.301000e-08 0 9.680000e-08 0 9.681000e-08 0.7 9.700000e-08 0.7 9.701000e-08 0 1.008000e-07 0
+ 1.008100e-07 0.7 1.010000e-07 0.7 1.010100e-07 0 1.048000e-07 0 1.048100e-07 0.7 1.050000e-07 0.7
+ 1.050100e-07 0 1.088000e-07 0 1.088100e-07 0.7 1.090000e-07 0.7 1.090100e-07 0 1.128000e-07 0
+ 1.128100e-07 0.7 1.130000e-07 0.7 1.130100e-07 0 1.168000e-07 0 1.168100e-07 0.7 1.170000e-07 0.7
+ 1.170100e-07 0 1.208000e-07 0 1.208100e-07 0.7 1.210000e-07 0.7 1.210100e-07 0 1.248000e-07 0
+ 1.248100e-07 0.7 1.250000e-07 0.7 1.250100e-07 0 1.288000e-07 0 1.288100e-07 0.7 1.290000e-07 0.7
+ 1.290100e-07 0 1.328000e-07 0 1.328100e-07 0.7 1.330000e-07 0.7 1.330100e-07 0 1.368000e-07 0
+ 1.368100e-07 0.7 1.370000e-07 0.7 1.370100e-07 0 1.408000e-07 0 1.408100e-07 0.7 1.410000e-07 0.7
+ 1.410100e-07 0 1.448000e-07 0 1.448100e-07 0.7 1.450000e-07 0.7 1.450100e-07 0 1.488000e-07 0
+ 1.488100e-07 0.7 1.490000e-07 0.7 1.490100e-07 0 1.528000e-07 0 1.528100e-07 0.7 1.530000e-07 0.7
+ 1.530100e-07 0 1.568000e-07 0 1.568100e-07 0.7 1.570000e-07 0.7 1.570100e-07 0 1.608000e-07 0
+ 1.608100e-07 0.7 1.610000e-07 0.7 1.610100e-07 0 1.648000e-07 0 1.648100e-07 0.7 1.650000e-07 0.7
+ 1.650100e-07 0 1.688000e-07 0 1.688100e-07 0.7 1.690000e-07 0.7 1.690100e-07 0 1.728000e-07 0
+ 1.728100e-07 0.7 1.730000e-07 0.7 1.730100e-07 0 1.768000e-07 0 1.768100e-07 0.7 1.770000e-07 0.7
+ 1.770100e-07 0 1.808000e-07 0 1.808100e-07 0.7 1.810000e-07 0.7 1.810100e-07 0 1.848000e-07 0
+ 1.848100e-07 0.7 1.850000e-07 0.7 1.850100e-07 0 1.888000e-07 0 1.888100e-07 0.7 1.890000e-07 0.7
+ 1.890100e-07 0 1.928000e-07 0 1.928100e-07 0.7 1.930000e-07 0.7 1.930100e-07 0 1.968000e-07 0
+ 1.968100e-07 0.7 1.970000e-07 0.7 1.970100e-07 0 2.008000e-07 0 2.008100e-07 0.7 2.010000e-07 0.7
+ 2.010100e-07 0 2.048000e-07 0 2.048100e-07 0.7 2.050000e-07 0.7 2.050100e-07 0 2.088000e-07 0
+ 2.088100e-07 0.7 2.090000e-07 0.7 2.090100e-07 0 2.128000e-07 0 2.128100e-07 0.7 2.130000e-07 0.7
+ 2.130100e-07 0 2.168000e-07 0 2.168100e-07 0.7 2.170000e-07 0.7 2.170100e-07 0 2.208000e-07 0
+ 2.208100e-07 0.7 2.210000e-07 0.7 2.210100e-07 0 2.248000e-07 0 2.248100e-07 0.7 2.250000e-07 0.7
+ 2.250100e-07 0 2.288000e-07 0 2.288100e-07 0.7 2.290000e-07 0.7 2.290100e-07 0 2.328000e-07 0
+ 2.328100e-07 0.7 2.330000e-07 0.7 2.330100e-07 0 2.368000e-07 0 2.368100e-07 0.7 2.370000e-07 0.7
+ 2.370100e-07 0 2.408000e-07 0 2.408100e-07 0.7 2.410000e-07 0.7 2.410100e-07 0 2.448000e-07 0
+ 2.448100e-07 0.7 2.450000e-07 0.7 2.450100e-07 0 2.488000e-07 0 2.488100e-07 0.7 2.490000e-07 0.7
+ 2.490100e-07 0 2.528000e-07 0 2.528100e-07 0.7 2.530000e-07 0.7 2.530100e-07 0 2.568000e-07 0
+ 2.568100e-07 0.7 2.570000e-07 0.7 2.570100e-07 0 2.608000e-07 0 2.608100e-07 0.7 2.610000e-07 0.7
+ 2.610100e-07 0 2.648000e-07 0 2.648100e-07 0.7 2.650000e-07 0.7 2.650100e-07 0 2.688000e-07 0
+ 2.688100e-07 0.7 2.690000e-07 0.7 2.690100e-07 0 2.728000e-07 0 2.728100e-07 0.7 2.730000e-07 0.7
+ 2.730100e-07 0 2.768000e-07 0 2.768100e-07 0.7 2.770000e-07 0.7 2.770100e-07 0 2.808000e-07 0
+ 2.808100e-07 0.7 2.810000e-07 0.7 2.810100e-07 0 2.848000e-07 0 2.848100e-07 0.7 2.850000e-07 0.7
+ 2.850100e-07 0 2.888000e-07 0 2.888100e-07 0.7 2.890000e-07 0.7 2.890100e-07 0 2.928000e-07 0
+ 2.928100e-07 0.7 2.930000e-07 0.7 2.930100e-07 0 2.968000e-07 0 2.968100e-07 0.7 2.970000e-07 0.7
+ 2.970100e-07 0 3.008000e-07 0 3.008100e-07 0.7 3.010000e-07 0.7 3.010100e-07 0 3.048000e-07 0
+ 3.048100e-07 0.7 3.050000e-07 0.7 3.050100e-07 0 3.088000e-07 0 3.088100e-07 0.7 3.090000e-07 0.7
+ 3.090100e-07 0 3.128000e-07 0 3.128100e-07 0.7 3.130000e-07 0.7 3.130100e-07 0 3.168000e-07 0
+ 3.168100e-07 0.7 3.170000e-07 0.7 3.170100e-07 0 3.208000e-07 0 3.208100e-07 0.7 3.210000e-07 0.7
+ 3.210100e-07 0 3.248000e-07 0 3.248100e-07 0.7 3.250000e-07 0.7 3.250100e-07 0 3.288000e-07 0
+ 3.288100e-07 0.7 3.290000e-07 0.7 3.290100e-07 0 3.328000e-07 0 3.328100e-07 0.7 3.330000e-07 0.7
+ 3.330100e-07 0 3.368000e-07 0 3.368100e-07 0.7 3.370000e-07 0.7 3.370100e-07 0 3.408000e-07 0
+ 3.408100e-07 0.7 3.410000e-07 0.7 3.410100e-07 0 3.448000e-07 0 3.448100e-07 0.7 3.450000e-07 0.7
+ 3.450100e-07 0 3.488000e-07 0 3.488100e-07 0.7 3.490000e-07 0.7 3.490100e-07 0 3.528000e-07 0
+ 3.528100e-07 0.7 3.530000e-07 0.7 3.530100e-07 0 3.568000e-07 0 3.568100e-07 0.7 3.570000e-07 0.7
+ 3.570100e-07 0 3.608000e-07 0 3.608100e-07 0.7 3.610000e-07 0.7 3.610100e-07 0 3.648000e-07 0
+ 3.648100e-07 0.7 3.650000e-07 0.7 3.650100e-07 0 3.688000e-07 0 3.688100e-07 0.7 3.690000e-07 0.7
+ 3.690100e-07 0 3.728000e-07 0 3.728100e-07 0.7 3.730000e-07 0.7 3.730100e-07 0 3.768000e-07 0
+ 3.768100e-07 0.7 3.770000e-07 0.7 3.770100e-07 0 3.808000e-07 0 3.808100e-07 0.7 3.810000e-07 0.7
+ 3.810100e-07 0 3.848000e-07 0 3.848100e-07 0.7 3.850000e-07 0.7 3.850100e-07 0 3.888000e-07 0
+ 3.888100e-07 0.7 3.890000e-07 0.7 3.890100e-07 0 3.928000e-07 0 3.928100e-07 0.7 3.930000e-07 0.7
+ 3.930100e-07 0 3.968000e-07 0 3.968100e-07 0.7 3.970000e-07 0.7 3.970100e-07 0 4.008000e-07 0
+ 4.008100e-07 0.7 4.010000e-07 0.7 4.010100e-07 0 4.048000e-07 0 4.048100e-07 0.7 4.050000e-07 0.7
+ 4.050100e-07 0 4.088000e-07 0 4.088100e-07 0.7 4.090000e-07 0.7 4.090100e-07 0 4.128000e-07 0
+ 4.128100e-07 0.7 4.130000e-07 0.7 4.130100e-07 0 4.168000e-07 0 4.168100e-07 0.7 4.170000e-07 0.7
+ 4.170100e-07 0 4.208000e-07 0 4.208100e-07 0.7 4.210000e-07 0.7 4.210100e-07 0 4.248000e-07 0
+ 4.248100e-07 0.7 4.250000e-07 0.7 4.250100e-07 0 4.288000e-07 0 4.288100e-07 0.7 4.290000e-07 0.7
+ 4.290100e-07 0 4.328000e-07 0 4.328100e-07 0.7 4.330000e-07 0.7 4.330100e-07 0 4.368000e-07 0
+ 4.368100e-07 0.7 4.370000e-07 0.7 4.370100e-07 0 4.408000e-07 0 4.408100e-07 0.7 4.410000e-07 0.7
+ 4.410100e-07 0 4.448000e-07 0 4.448100e-07 0.7 4.450000e-07 0.7 4.450100e-07 0 4.488000e-07 0
+ 4.488100e-07 0.7 4.490000e-07 0.7 4.490100e-07 0 4.528000e-07 0 4.528100e-07 0.7 4.530000e-07 0.7
+ 4.530100e-07 0 4.568000e-07 0 4.568100e-07 0.7 4.570000e-07 0.7 4.570100e-07 0 4.608000e-07 0
+ 4.608100e-07 0.7 4.610000e-07 0.7 4.610100e-07 0 4.648000e-07 0 4.648100e-07 0.7 4.650000e-07 0.7
+ 4.650100e-07 0 4.688000e-07 0 4.688100e-07 0.7 4.690000e-07 0.7 4.690100e-07 0 4.728000e-07 0
+ 4.728100e-07 0.7 4.730000e-07 0.7 4.730100e-07 0 4.768000e-07 0 4.768100e-07 0.7 4.770000e-07 0.7
+ 4.770100e-07 0 4.808000e-07 0 4.808100e-07 0.7 4.810000e-07 0.7 4.810100e-07 0 4.848000e-07 0
+ 4.848100e-07 0.7 4.850000e-07 0.7 4.850100e-07 0 4.888000e-07 0 4.888100e-07 0.7 4.890000e-07 0.7
+ 4.890100e-07 0 4.928000e-07 0 4.928100e-07 0.7 4.930000e-07 0.7 4.930100e-07 0 4.968000e-07 0
+ 4.968100e-07 0.7 4.970000e-07 0.7 4.970100e-07 0 5.008000e-07 0 5.008100e-07 0.7 5.010000e-07 0.7
+ 5.010100e-07 0 5.048000e-07 0 5.048100e-07 0.7 5.050000e-07 0.7 5.050100e-07 0 5.088000e-07 0
+ 5.088100e-07 0.7 5.090000e-07 0.7 5.090100e-07 0 5.128000e-07 0 5.128100e-07 0.7 5.130000e-07 0.7
+ 5.130100e-07 0 5.168000e-07 0 5.168100e-07 0.7 5.170000e-07 0.7 5.170100e-07 0 5.208000e-07 0
+ 5.208100e-07 0.7 5.210000e-07 0.7 5.210100e-07 0 5.248000e-07 0 5.248100e-07 0.7 5.250000e-07 0.7
+ 5.250100e-07 0 5.288000e-07 0 5.288100e-07 0.7 5.290000e-07 0.7 5.290100e-07 0 5.328000e-07 0
+ 5.328100e-07 0.7 5.330000e-07 0.7 5.330100e-07 0 5.368000e-07 0 5.368100e-07 0.7 5.370000e-07 0.7
+ 5.370100e-07 0 5.408000e-07 0 5.408100e-07 0.7 5.410000e-07 0.7 5.410100e-07 0 5.448000e-07 0
+ 5.448100e-07 0.7 5.450000e-07 0.7 5.450100e-07 0 5.488000e-07 0 5.488100e-07 0.7 5.490000e-07 0.7
+ 5.490100e-07 0 5.528000e-07 0 5.528100e-07 0.7 5.530000e-07 0.7 5.530100e-07 0 5.568000e-07 0
+ 5.568100e-07 0.7 5.570000e-07 0.7 5.570100e-07 0 5.608000e-07 0 5.608100e-07 0.7 5.610000e-07 0.7
+ 5.610100e-07 0 5.648000e-07 0 5.648100e-07 0.7 5.650000e-07 0.7 5.650100e-07 0 5.688000e-07 0
+ 5.688100e-07 0.7 5.690000e-07 0.7 5.690100e-07 0 5.728000e-07 0 5.728100e-07 0.7 5.730000e-07 0.7
+ 5.730100e-07 0 5.768000e-07 0 5.768100e-07 0.7 5.770000e-07 0.7 5.770100e-07 0 5.808000e-07 0
+ 5.808100e-07 0.7 5.810000e-07 0.7 5.810100e-07 0 5.848000e-07 0 5.848100e-07 0.7 5.850000e-07 0.7
+ 5.850100e-07 0 5.888000e-07 0 5.888100e-07 0.7 5.890000e-07 0.7 5.890100e-07 0 5.928000e-07 0
+ 5.928100e-07 0.7 5.930000e-07 0.7 5.930100e-07 0 5.968000e-07 0 5.968100e-07 0.7 5.970000e-07 0.7
+ 5.970100e-07 0 6.008000e-07 0 6.008100e-07 0.7 6.010000e-07 0.7 6.010100e-07 0 6.048000e-07 0
+ 6.048100e-07 0.7 6.050000e-07 0.7 6.050100e-07 0 6.088000e-07 0 6.088100e-07 0.7 6.090000e-07 0.7
+ 6.090100e-07 0 6.128000e-07 0 6.128100e-07 0.7 6.130000e-07 0.7 6.130100e-07 0 6.168000e-07 0
+ 6.168100e-07 0.7 6.170000e-07 0.7 6.170100e-07 0 6.208000e-07 0 6.208100e-07 0.7 6.210000e-07 0.7
+ 6.210100e-07 0 6.248000e-07 0 6.248100e-07 0.7 6.250000e-07 0.7 6.250100e-07 0 6.288000e-07 0
+ 6.288100e-07 0.7 6.290000e-07 0.7 6.290100e-07 0 6.328000e-07 0 6.328100e-07 0.7 6.330000e-07 0.7
+ 6.330100e-07 0 6.368000e-07 0 6.368100e-07 0.7 6.370000e-07 0.7 6.370100e-07 0 6.408000e-07 0
+ 6.408100e-07 0.7 6.410000e-07 0.7 6.410100e-07 0 6.448000e-07 0 6.448100e-07 0.7 6.450000e-07 0.7
+ 6.450100e-07 0 6.482000e-07 0 6.482100e-07 0.7 6.484000e-07 0.7 6.484100e-07 0 6.486000e-07 0
+ 6.486100e-07 0.7 6.488000e-07 0.7 6.488100e-07 0 6.490000e-07 0 6.490100e-07 0.7 6.524000e-07 0.7
+ 6.524100e-07 0 6.526000e-07 0 6.526100e-07 0.7 6.528000e-07 0.7 6.528100e-07 0 6.530000e-07 0
+ 6.530100e-07 0.7 6.564000e-07 0.7 6.564100e-07 0 6.566000e-07 0 6.566100e-07 0.7 6.568000e-07 0.7
+ 6.568100e-07 0 6.570000e-07 0 6.570100e-07 0.7 6.604000e-07 0.7 6.604100e-07 0 6.606000e-07 0
+ 6.606100e-07 0.7 6.608000e-07 0.7 6.608100e-07 0 6.610000e-07 0 6.610100e-07 0.7 6.644000e-07 0.7
+ 6.644100e-07 0 6.646000e-07 0 6.646100e-07 0.7 6.648000e-07 0.7 6.648100e-07 0 6.650000e-07 0
+ 6.650100e-07 0.7 6.684000e-07 0.7 6.684100e-07 0 6.686000e-07 0 6.686100e-07 0.7 6.688000e-07 0.7
+ 6.688100e-07 0 6.690000e-07 0 6.690100e-07 0.7 6.724000e-07 0.7 6.724100e-07 0 6.726000e-07 0
+ 6.726100e-07 0.7 6.728000e-07 0.7 6.728100e-07 0 6.730000e-07 0 6.730100e-07 0.7 6.764000e-07 0.7
+ 6.764100e-07 0 6.766000e-07 0 6.766100e-07 0.7 6.768000e-07 0.7 6.768100e-07 0 6.770000e-07 0
+ 6.770100e-07 0.7 6.804000e-07 0.7 6.804100e-07 0 6.806000e-07 0 6.806100e-07 0.7 6.808000e-07 0.7
+ 6.808100e-07 0 6.810000e-07 0 6.810100e-07 0.7 6.844000e-07 0.7 6.844100e-07 0 6.846000e-07 0
+ 6.846100e-07 0.7 6.848000e-07 0.7 6.848100e-07 0 6.850000e-07 0 6.850100e-07 0.7 6.884000e-07 0.7
+ 6.884100e-07 0 6.886000e-07 0 6.886100e-07 0.7 6.888000e-07 0.7 6.888100e-07 0 6.890000e-07 0
+ 6.890100e-07 0.7 6.924000e-07 0.7 6.924100e-07 0 6.926000e-07 0 6.926100e-07 0.7 6.928000e-07 0.7
+ 6.928100e-07 0 6.930000e-07 0 6.930100e-07 0.7 6.964000e-07 0.7 6.964100e-07 0 6.966000e-07 0
+ 6.966100e-07 0.7 6.968000e-07 0.7 6.968100e-07 0 6.970000e-07 0 6.970100e-07 0.7 7.004000e-07 0.7
+ 7.004100e-07 0 7.006000e-07 0 7.006100e-07 0.7 7.008000e-07 0.7 7.008100e-07 0 7.010000e-07 0
+ 7.010100e-07 0.7 7.044000e-07 0.7 7.044100e-07 0 7.046000e-07 0 7.046100e-07 0.7 7.048000e-07 0.7
+ 7.048100e-07 0 7.050000e-07 0 7.050100e-07 0.7 7.084000e-07 0.7 7.084100e-07 0 7.086000e-07 0
+ 7.086100e-07 0.7 7.088000e-07 0.7 7.088100e-07 0 7.090000e-07 0 7.090100e-07 0.7 7.124000e-07 0.7
+ 7.124100e-07 0 7.126000e-07 0 7.126100e-07 0.7 7.128000e-07 0.7 7.128100e-07 0 7.130000e-07 0
+ 7.130100e-07 0.7 7.164000e-07 0.7 7.164100e-07 0 7.166000e-07 0 7.166100e-07 0.7 7.168000e-07 0.7
+ 7.168100e-07 0 7.170000e-07 0 7.170100e-07 0.7 7.204000e-07 0.7 7.204100e-07 0 7.206000e-07 0
+ 7.206100e-07 0.7 7.208000e-07 0.7 7.208100e-07 0 7.210000e-07 0 7.210100e-07 0.7 7.244000e-07 0.7
+ 7.244100e-07 0 7.246000e-07 0 7.246100e-07 0.7 7.248000e-07 0.7 7.248100e-07 0 7.250000e-07 0
+ 7.250100e-07 0.7 7.284000e-07 0.7 7.284100e-07 0 7.286000e-07 0 7.286100e-07 0.7 7.288000e-07 0.7
+ 7.288100e-07 0 7.290000e-07 0 7.290100e-07 0.7 7.324000e-07 0.7 7.324100e-07 0 7.326000e-07 0
+ 7.326100e-07 0.7 7.328000e-07 0.7 7.328100e-07 0 7.330000e-07 0 7.330100e-07 0.7 7.364000e-07 0.7
+ 7.364100e-07 0 7.366000e-07 0 7.366100e-07 0.7 7.368000e-07 0.7 7.368100e-07 0 7.370000e-07 0
+ 7.370100e-07 0.7 7.404000e-07 0.7 7.404100e-07 0 7.406000e-07 0 7.406100e-07 0.7 7.408000e-07 0.7
+ 7.408100e-07 0 7.410000e-07 0 7.410100e-07 0.7 7.444000e-07 0.7 7.444100e-07 0 7.446000e-07 0
+ 7.446100e-07 0.7 7.448000e-07 0.7 7.448100e-07 0 7.450000e-07 0 7.450100e-07 0.7 7.484000e-07 0.7
+ 7.484100e-07 0 7.486000e-07 0 7.486100e-07 0.7 7.488000e-07 0.7 7.488100e-07 0 7.490000e-07 0
+ 7.490100e-07 0.7 7.524000e-07 0.7 7.524100e-07 0 7.526000e-07 0 7.526100e-07 0.7 7.528000e-07 0.7
+ 7.528100e-07 0 7.530000e-07 0 7.530100e-07 0.7 7.564000e-07 0.7 7.564100e-07 0 7.566000e-07 0
+ 7.566100e-07 0.7 7.568000e-07 0.7 7.568100e-07 0 7.570000e-07 0 7.570100e-07 0.7 7.604000e-07 0.7
+ 7.604100e-07 0 7.606000e-07 0 7.606100e-07 0.7 7.608000e-07 0.7 7.608100e-07 0 7.610000e-07 0
+ 7.610100e-07 0.7 7.644000e-07 0.7 7.644100e-07 0 7.646000e-07 0 7.646100e-07 0.7 7.648000e-07 0.7
+ 7.648100e-07 0 7.650000e-07 0 7.650100e-07 0.7 7.684000e-07 0.7 7.684100e-07 0 7.686000e-07 0
+ 7.686100e-07 0.7 7.688000e-07 0.7 7.688100e-07 0 7.690000e-07 0 7.690100e-07 0.7 7.724000e-07 0.7
+ 7.724100e-07 0 7.726000e-07 0 7.726100e-07 0.7 7.728000e-07 0.7 7.728100e-07 0 7.730000e-07 0
+ 7.730100e-07 0.7 7.764000e-07 0.7 7.764100e-07 0 7.766000e-07 0 7.766100e-07 0.7 7.768000e-07 0.7
+ 7.768100e-07 0 7.770000e-07 0 7.770100e-07 0.7 7.804000e-07 0.7 7.804100e-07 0 7.806000e-07 0
+ 7.806100e-07 0.7 7.808000e-07 0.7 7.808100e-07 0 7.810000e-07 0 7.810100e-07 0.7 7.844000e-07 0.7
+ 7.844100e-07 0 7.846000e-07 0 7.846100e-07 0.7 7.848000e-07 0.7 7.848100e-07 0 7.850000e-07 0
+ 7.850100e-07 0.7 7.884000e-07 0.7 7.884100e-07 0 7.886000e-07 0 7.886100e-07 0.7 7.888000e-07 0.7
+ 7.888100e-07 0 7.890000e-07 0 7.890100e-07 0.7 7.924000e-07 0.7 7.924100e-07 0 7.926000e-07 0
+ 7.926100e-07 0.7 7.928000e-07 0.7 7.928100e-07 0 7.930000e-07 0 7.930100e-07 0.7 7.964000e-07 0.7
+ 7.964100e-07 0 7.966000e-07 0 7.966100e-07 0.7 7.968000e-07 0.7 7.968100e-07 0 7.970000e-07 0
+ 7.970100e-07 0.7 8.004000e-07 0.7 8.004100e-07 0 8.006000e-07 0 8.006100e-07 0.7 8.008000e-07 0.7
+ 8.008100e-07 0 8.010000e-07 0 8.010100e-07 0.7 8.044000e-07 0.7 8.044100e-07 0 8.046000e-07 0
+ 8.046100e-07 0.7 8.048000e-07 0.7 8.048100e-07 0 8.050000e-07 0 8.050100e-07 0.7 8.084000e-07 0.7
+ 8.084100e-07 0 8.086000e-07 0 8.086100e-07 0.7 8.088000e-07 0.7 8.088100e-07 0 8.090000e-07 0
+ 8.090100e-07 0.7 8.124000e-07 0.7 8.124100e-07 0 8.126000e-07 0 8.126100e-07 0.7 8.128000e-07 0.7
+ 8.128100e-07 0 8.130000e-07 0 8.130100e-07 0.7 8.164000e-07 0.7 8.164100e-07 0 8.166000e-07 0
+ 8.166100e-07 0.7 8.168000e-07 0.7 8.168100e-07 0 8.170000e-07 0 8.170100e-07 0.7 8.204000e-07 0.7
+ 8.204100e-07 0 8.206000e-07 0 8.206100e-07 0.7 8.208000e-07 0.7 8.208100e-07 0 8.210000e-07 0
+ 8.210100e-07 0.7 8.244000e-07 0.7 8.244100e-07 0 8.246000e-07 0 8.246100e-07 0.7 8.248000e-07 0.7
+ 8.248100e-07 0 8.250000e-07 0 8.250100e-07 0.7 8.284000e-07 0.7 8.284100e-07 0 8.286000e-07 0
+ 8.286100e-07 0.7 8.288000e-07 0.7 8.288100e-07 0 8.290000e-07 0 8.290100e-07 0.7 8.324000e-07 0.7
+ 8.324100e-07 0 8.326000e-07 0 8.326100e-07 0.7 8.328000e-07 0.7 8.328100e-07 0 8.330000e-07 0
+ 8.330100e-07 0.7 8.364000e-07 0.7 8.364100e-07 0 8.366000e-07 0 8.366100e-07 0.7 8.368000e-07 0.7
+ 8.368100e-07 0 8.370000e-07 0 8.370100e-07 0.7 8.404000e-07 0.7 8.404100e-07 0 8.406000e-07 0
+ 8.406100e-07 0.7 8.408000e-07 0.7 8.408100e-07 0 8.410000e-07 0 8.410100e-07 0.7 8.444000e-07 0.7
+ 8.444100e-07 0 8.446000e-07 0 8.446100e-07 0.7 8.448000e-07 0.7 8.448100e-07 0 8.450000e-07 0
+ 8.450100e-07 0.7 8.484000e-07 0.7 8.484100e-07 0 8.486000e-07 0 8.486100e-07 0.7 8.488000e-07 0.7
+ 8.488100e-07 0 8.490000e-07 0 8.490100e-07 0.7 8.524000e-07 0.7 8.524100e-07 0 8.526000e-07 0
+ 8.526100e-07 0.7 8.528000e-07 0.7 8.528100e-07 0 8.530000e-07 0 8.530100e-07 0.7 8.564000e-07 0.7
+ 8.564100e-07 0 8.566000e-07 0 8.566100e-07 0.7 8.568000e-07 0.7 8.568100e-07 0 8.570000e-07 0
+ 8.570100e-07 0.7 8.604000e-07 0.7 8.604100e-07 0 8.606000e-07 0 8.606100e-07 0.7 8.608000e-07 0.7
+ 8.608100e-07 0 8.610000e-07 0 8.610100e-07 0.7 8.644000e-07 0.7 8.644100e-07 0 8.646000e-07 0
+ 8.646100e-07 0.7 8.648000e-07 0.7 8.648100e-07 0 8.650000e-07 0 8.650100e-07 0.7 8.684000e-07 0.7
+ 8.684100e-07 0 8.686000e-07 0 8.686100e-07 0.7 8.688000e-07 0.7 8.688100e-07 0 8.690000e-07 0
+ 8.690100e-07 0.7 8.724000e-07 0.7 8.724100e-07 0 8.726000e-07 0 8.726100e-07 0.7 8.728000e-07 0.7
+ 8.728100e-07 0 8.730000e-07 0 8.730100e-07 0.7 8.764000e-07 0.7 8.764100e-07 0 8.766000e-07 0
+ 8.766100e-07 0.7 8.768000e-07 0.7 8.768100e-07 0 8.770000e-07 0 8.770100e-07 0.7 8.804000e-07 0.7
+ 8.804100e-07 0 8.806000e-07 0 8.806100e-07 0.7 8.808000e-07 0.7 8.808100e-07 0 8.810000e-07 0
+ 8.810100e-07 0.7 8.844000e-07 0.7 8.844100e-07 0 8.846000e-07 0 8.846100e-07 0.7 8.848000e-07 0.7
+ 8.848100e-07 0 8.850000e-07 0 8.850100e-07 0.7 8.884000e-07 0.7 8.884100e-07 0 8.886000e-07 0
+ 8.886100e-07 0.7 8.888000e-07 0.7 8.888100e-07 0 8.890000e-07 0 8.890100e-07 0.7 8.924000e-07 0.7
+ 8.924100e-07 0 8.926000e-07 0 8.926100e-07 0.7 8.928000e-07 0.7 8.928100e-07 0 8.930000e-07 0
+ 8.930100e-07 0.7 8.964000e-07 0.7 8.964100e-07 0 8.966000e-07 0 8.966100e-07 0.7 8.968000e-07 0.7
+ 8.968100e-07 0 8.970000e-07 0 8.970100e-07 0.7 9.004000e-07 0.7 9.004100e-07 0 9.006000e-07 0
+ 9.006100e-07 0.7 9.008000e-07 0.7 9.008100e-07 0 9.010000e-07 0 9.010100e-07 0.7 9.044000e-07 0.7
+ 9.044100e-07 0 9.046000e-07 0 9.046100e-07 0.7 9.048000e-07 0.7 9.048100e-07 0 9.050000e-07 0
+ 9.050100e-07 0.7 9.084000e-07 0.7 9.084100e-07 0 9.086000e-07 0 9.086100e-07 0.7 9.088000e-07 0.7
+ 9.088100e-07 0 9.090000e-07 0 9.090100e-07 0.7 9.124000e-07 0.7 9.124100e-07 0 9.126000e-07 0
+ 9.126100e-07 0.7 9.128000e-07 0.7 9.128100e-07 0 9.130000e-07 0 9.130100e-07 0.7 9.164000e-07 0.7
+ 9.164100e-07 0 9.166000e-07 0 9.166100e-07 0.7 9.168000e-07 0.7 9.168100e-07 0 9.170000e-07 0
+ 9.170100e-07 0.7 9.204000e-07 0.7 9.204100e-07 0 9.206000e-07 0 9.206100e-07 0.7 9.208000e-07 0.7
+ 9.208100e-07 0 9.210000e-07 0 9.210100e-07 0.7 9.244000e-07 0.7 9.244100e-07 0 9.246000e-07 0
+ 9.246100e-07 0.7 9.248000e-07 0.7 9.248100e-07 0 9.250000e-07 0 9.250100e-07 0.7 9.284000e-07 0.7
+ 9.284100e-07 0 9.286000e-07 0 9.286100e-07 0.7 9.288000e-07 0.7 9.288100e-07 0 9.290000e-07 0
+ 9.290100e-07 0.7 9.324000e-07 0.7 9.324100e-07 0 9.326000e-07 0 9.326100e-07 0.7 9.328000e-07 0.7
+ 9.328100e-07 0 9.330000e-07 0 9.330100e-07 0.7 9.364000e-07 0.7 9.364100e-07 0 9.366000e-07 0
+ 9.366100e-07 0.7 9.368000e-07 0.7 9.368100e-07 0 9.370000e-07 0 9.370100e-07 0.7 9.404000e-07 0.7
+ 9.404100e-07 0 9.406000e-07 0 9.406100e-07 0.7 9.408000e-07 0.7 9.408100e-07 0 9.410000e-07 0
+ 9.410100e-07 0.7 9.444000e-07 0.7 9.444100e-07 0 9.446000e-07 0 9.446100e-07 0.7 9.448000e-07 0.7
+ 9.448100e-07 0 9.450000e-07 0 9.450100e-07 0.7 9.484000e-07 0.7 9.484100e-07 0 9.486000e-07 0
+ 9.486100e-07 0.7 9.488000e-07 0.7 9.488100e-07 0 9.490000e-07 0 9.490100e-07 0.7 9.524000e-07 0.7
+ 9.524100e-07 0 9.526000e-07 0 9.526100e-07 0.7 9.528000e-07 0.7 9.528100e-07 0 9.530000e-07 0
+ 9.530100e-07 0.7 9.564000e-07 0.7 9.564100e-07 0 9.566000e-07 0 9.566100e-07 0.7 9.568000e-07 0.7
+ 9.568100e-07 0 9.570000e-07 0 9.570100e-07 0.7 9.604000e-07 0.7 9.604100e-07 0 9.606000e-07 0
+ 9.606100e-07 0.7 9.608000e-07 0.7 9.608100e-07 0 9.610000e-07 0 9.610100e-07 0.7 9.644000e-07 0.7
+ 9.644100e-07 0 9.646000e-07 0 9.646100e-07 0.7 9.648000e-07 0.7 9.648100e-07 0 9.650000e-07 0
+ 9.650100e-07 0.7 9.684000e-07 0.7 9.684100e-07 0 9.686000e-07 0 9.686100e-07 0.7 9.688000e-07 0.7
+ 9.688100e-07 0 9.690000e-07 0 9.690100e-07 0.7 )
v_WA0 src_WA0 0 pwl(
+ 0.000000e+00 0 1.200000e-09 0 1.210000e-09 0.7 1.400000e-09 0.7 1.410000e-09 0 1.600000e-09 0
+ 1.610000e-09 0.7 1.800000e-09 0.7 1.810000e-09 0 5.200000e-09 0 5.210000e-09 0.7 5.400000e-09 0.7
+ 5.410000e-09 0 5.600000e-09 0 5.610000e-09 0.7 5.800000e-09 0.7 5.810000e-09 0 9.200000e-09 0
+ 9.210000e-09 0.7 9.400000e-09 0.7 9.410000e-09 0 9.600000e-09 0 9.610000e-09 0.7 9.800000e-09 0.7
+ 9.810000e-09 0 1.320000e-08 0 1.321000e-08 0.7 1.340000e-08 0.7 1.341000e-08 0 1.360000e-08 0
+ 1.361000e-08 0.7 1.380000e-08 0.7 1.381000e-08 0 1.720000e-08 0 1.721000e-08 0.7 1.740000e-08 0.7
+ 1.741000e-08 0 1.760000e-08 0 1.761000e-08 0.7 1.780000e-08 0.7 1.781000e-08 0 2.120000e-08 0
+ 2.121000e-08 0.7 2.140000e-08 0.7 2.141000e-08 0 2.160000e-08 0 2.161000e-08 0.7 2.180000e-08 0.7
+ 2.181000e-08 0 2.520000e-08 0 2.521000e-08 0.7 2.540000e-08 0.7 2.541000e-08 0 2.560000e-08 0
+ 2.561000e-08 0.7 2.580000e-08 0.7 2.581000e-08 0 2.920000e-08 0 2.921000e-08 0.7 2.940000e-08 0.7
+ 2.941000e-08 0 2.960000e-08 0 2.961000e-08 0.7 2.980000e-08 0.7 2.981000e-08 0 3.320000e-08 0
+ 3.321000e-08 0.7 3.340000e-08 0.7 3.341000e-08 0 3.360000e-08 0 3.361000e-08 0.7 3.380000e-08 0.7
+ 3.381000e-08 0 3.720000e-08 0 3.721000e-08 0.7 3.740000e-08 0.7 3.741000e-08 0 3.760000e-08 0
+ 3.761000e-08 0.7 3.780000e-08 0.7 3.781000e-08 0 4.120000e-08 0 4.121000e-08 0.7 4.140000e-08 0.7
+ 4.141000e-08 0 4.160000e-08 0 4.161000e-08 0.7 4.180000e-08 0.7 4.181000e-08 0 4.520000e-08 0
+ 4.521000e-08 0.7 4.540000e-08 0.7 4.541000e-08 0 4.560000e-08 0 4.561000e-08 0.7 4.580000e-08 0.7
+ 4.581000e-08 0 4.920000e-08 0 4.921000e-08 0.7 4.940000e-08 0.7 4.941000e-08 0 4.960000e-08 0
+ 4.961000e-08 0.7 4.980000e-08 0.7 4.981000e-08 0 5.320000e-08 0 5.321000e-08 0.7 5.340000e-08 0.7
+ 5.341000e-08 0 5.360000e-08 0 5.361000e-08 0.7 5.380000e-08 0.7 5.381000e-08 0 5.720000e-08 0
+ 5.721000e-08 0.7 5.740000e-08 0.7 5.741000e-08 0 5.760000e-08 0 5.761000e-08 0.7 5.780000e-08 0.7
+ 5.781000e-08 0 6.120000e-08 0 6.121000e-08 0.7 6.140000e-08 0.7 6.141000e-08 0 6.160000e-08 0
+ 6.161000e-08 0.7 6.180000e-08 0.7 6.181000e-08 0 6.520000e-08 0 6.521000e-08 0.7 6.540000e-08 0.7
+ 6.541000e-08 0 6.560000e-08 0 6.561000e-08 0.7 6.580000e-08 0.7 6.581000e-08 0 6.920000e-08 0
+ 6.921000e-08 0.7 6.940000e-08 0.7 6.941000e-08 0 6.960000e-08 0 6.961000e-08 0.7 6.980000e-08 0.7
+ 6.981000e-08 0 7.320000e-08 0 7.321000e-08 0.7 7.340000e-08 0.7 7.341000e-08 0 7.360000e-08 0
+ 7.361000e-08 0.7 7.380000e-08 0.7 7.381000e-08 0 7.720000e-08 0 7.721000e-08 0.7 7.740000e-08 0.7
+ 7.741000e-08 0 7.760000e-08 0 7.761000e-08 0.7 7.780000e-08 0.7 7.781000e-08 0 8.120000e-08 0
+ 8.121000e-08 0.7 8.140000e-08 0.7 8.141000e-08 0 8.160000e-08 0 8.161000e-08 0.7 8.180000e-08 0.7
+ 8.181000e-08 0 8.520000e-08 0 8.521000e-08 0.7 8.540000e-08 0.7 8.541000e-08 0 8.560000e-08 0
+ 8.561000e-08 0.7 8.580000e-08 0.7 8.581000e-08 0 8.920000e-08 0 8.921000e-08 0.7 8.940000e-08 0.7
+ 8.941000e-08 0 8.960000e-08 0 8.961000e-08 0.7 8.980000e-08 0.7 8.981000e-08 0 9.320000e-08 0
+ 9.321000e-08 0.7 9.340000e-08 0.7 9.341000e-08 0 9.360000e-08 0 9.361000e-08 0.7 9.380000e-08 0.7
+ 9.381000e-08 0 9.720000e-08 0 9.721000e-08 0.7 9.740000e-08 0.7 9.741000e-08 0 9.760000e-08 0
+ 9.761000e-08 0.7 9.780000e-08 0.7 9.781000e-08 0 1.012000e-07 0 1.012100e-07 0.7 1.014000e-07 0.7
+ 1.014100e-07 0 1.016000e-07 0 1.016100e-07 0.7 1.018000e-07 0.7 1.018100e-07 0 1.052000e-07 0
+ 1.052100e-07 0.7 1.054000e-07 0.7 1.054100e-07 0 1.056000e-07 0 1.056100e-07 0.7 1.058000e-07 0.7
+ 1.058100e-07 0 1.082000e-07 0 1.082100e-07 0.7 1.092000e-07 0.7 1.092100e-07 0 1.094000e-07 0
+ 1.094100e-07 0.7 1.132000e-07 0.7 1.132100e-07 0 1.134000e-07 0 1.134100e-07 0.7 1.172000e-07 0.7
+ 1.172100e-07 0 1.174000e-07 0 1.174100e-07 0.7 1.212000e-07 0.7 1.212100e-07 0 1.214000e-07 0
+ 1.214100e-07 0.7 1.252000e-07 0.7 1.252100e-07 0 1.254000e-07 0 1.254100e-07 0.7 1.292000e-07 0.7
+ 1.292100e-07 0 1.294000e-07 0 1.294100e-07 0.7 1.332000e-07 0.7 1.332100e-07 0 1.334000e-07 0
+ 1.334100e-07 0.7 1.372000e-07 0.7 1.372100e-07 0 1.374000e-07 0 1.374100e-07 0.7 1.412000e-07 0.7
+ 1.412100e-07 0 1.414000e-07 0 1.414100e-07 0.7 1.452000e-07 0.7 1.452100e-07 0 1.454000e-07 0
+ 1.454100e-07 0.7 1.492000e-07 0.7 1.492100e-07 0 1.494000e-07 0 1.494100e-07 0.7 1.532000e-07 0.7
+ 1.532100e-07 0 1.534000e-07 0 1.534100e-07 0.7 1.572000e-07 0.7 1.572100e-07 0 1.574000e-07 0
+ 1.574100e-07 0.7 1.612000e-07 0.7 1.612100e-07 0 1.614000e-07 0 1.614100e-07 0.7 1.652000e-07 0.7
+ 1.652100e-07 0 1.654000e-07 0 1.654100e-07 0.7 1.692000e-07 0.7 1.692100e-07 0 1.694000e-07 0
+ 1.694100e-07 0.7 1.732000e-07 0.7 1.732100e-07 0 1.734000e-07 0 1.734100e-07 0.7 1.772000e-07 0.7
+ 1.772100e-07 0 1.774000e-07 0 1.774100e-07 0.7 1.812000e-07 0.7 1.812100e-07 0 1.814000e-07 0
+ 1.814100e-07 0.7 1.852000e-07 0.7 1.852100e-07 0 1.854000e-07 0 1.854100e-07 0.7 1.892000e-07 0.7
+ 1.892100e-07 0 1.894000e-07 0 1.894100e-07 0.7 1.932000e-07 0.7 1.932100e-07 0 1.934000e-07 0
+ 1.934100e-07 0.7 1.972000e-07 0.7 1.972100e-07 0 1.974000e-07 0 1.974100e-07 0.7 2.012000e-07 0.7
+ 2.012100e-07 0 2.014000e-07 0 2.014100e-07 0.7 2.052000e-07 0.7 2.052100e-07 0 2.054000e-07 0
+ 2.054100e-07 0.7 2.092000e-07 0.7 2.092100e-07 0 2.094000e-07 0 2.094100e-07 0.7 2.132000e-07 0.7
+ 2.132100e-07 0 2.134000e-07 0 2.134100e-07 0.7 2.172000e-07 0.7 2.172100e-07 0 2.174000e-07 0
+ 2.174100e-07 0.7 2.212000e-07 0.7 2.212100e-07 0 2.214000e-07 0 2.214100e-07 0.7 2.252000e-07 0.7
+ 2.252100e-07 0 2.254000e-07 0 2.254100e-07 0.7 2.292000e-07 0.7 2.292100e-07 0 2.294000e-07 0
+ 2.294100e-07 0.7 2.332000e-07 0.7 2.332100e-07 0 2.334000e-07 0 2.334100e-07 0.7 2.372000e-07 0.7
+ 2.372100e-07 0 2.374000e-07 0 2.374100e-07 0.7 2.412000e-07 0.7 2.412100e-07 0 2.414000e-07 0
+ 2.414100e-07 0.7 2.452000e-07 0.7 2.452100e-07 0 2.454000e-07 0 2.454100e-07 0.7 2.492000e-07 0.7
+ 2.492100e-07 0 2.494000e-07 0 2.494100e-07 0.7 2.532000e-07 0.7 2.532100e-07 0 2.534000e-07 0
+ 2.534100e-07 0.7 2.572000e-07 0.7 2.572100e-07 0 2.574000e-07 0 2.574100e-07 0.7 2.612000e-07 0.7
+ 2.612100e-07 0 2.614000e-07 0 2.614100e-07 0.7 2.652000e-07 0.7 2.652100e-07 0 2.654000e-07 0
+ 2.654100e-07 0.7 2.692000e-07 0.7 2.692100e-07 0 2.694000e-07 0 2.694100e-07 0.7 2.732000e-07 0.7
+ 2.732100e-07 0 2.734000e-07 0 2.734100e-07 0.7 2.772000e-07 0.7 2.772100e-07 0 2.774000e-07 0
+ 2.774100e-07 0.7 2.812000e-07 0.7 2.812100e-07 0 2.814000e-07 0 2.814100e-07 0.7 2.852000e-07 0.7
+ 2.852100e-07 0 2.854000e-07 0 2.854100e-07 0.7 2.892000e-07 0.7 2.892100e-07 0 2.894000e-07 0
+ 2.894100e-07 0.7 2.932000e-07 0.7 2.932100e-07 0 2.934000e-07 0 2.934100e-07 0.7 2.972000e-07 0.7
+ 2.972100e-07 0 2.974000e-07 0 2.974100e-07 0.7 3.012000e-07 0.7 3.012100e-07 0 3.014000e-07 0
+ 3.014100e-07 0.7 3.052000e-07 0.7 3.052100e-07 0 3.054000e-07 0 3.054100e-07 0.7 3.092000e-07 0.7
+ 3.092100e-07 0 3.094000e-07 0 3.094100e-07 0.7 3.132000e-07 0.7 3.132100e-07 0 3.134000e-07 0
+ 3.134100e-07 0.7 3.172000e-07 0.7 3.172100e-07 0 3.174000e-07 0 3.174100e-07 0.7 3.212000e-07 0.7
+ 3.212100e-07 0 3.214000e-07 0 3.214100e-07 0.7 3.242000e-07 0.7 3.242100e-07 0 3.252000e-07 0
+ 3.252100e-07 0.7 3.254000e-07 0.7 3.254100e-07 0 3.256000e-07 0 3.256100e-07 0.7 3.258000e-07 0.7
+ 3.258100e-07 0 3.292000e-07 0 3.292100e-07 0.7 3.294000e-07 0.7 3.294100e-07 0 3.296000e-07 0
+ 3.296100e-07 0.7 3.298000e-07 0.7 3.298100e-07 0 3.332000e-07 0 3.332100e-07 0.7 3.334000e-07 0.7
+ 3.334100e-07 0 3.336000e-07 0 3.336100e-07 0.7 3.338000e-07 0.7 3.338100e-07 0 3.372000e-07 0
+ 3.372100e-07 0.7 3.374000e-07 0.7 3.374100e-07 0 3.376000e-07 0 3.376100e-07 0.7 3.378000e-07 0.7
+ 3.378100e-07 0 3.412000e-07 0 3.412100e-07 0.7 3.414000e-07 0.7 3.414100e-07 0 3.416000e-07 0
+ 3.416100e-07 0.7 3.418000e-07 0.7 3.418100e-07 0 3.452000e-07 0 3.452100e-07 0.7 3.454000e-07 0.7
+ 3.454100e-07 0 3.456000e-07 0 3.456100e-07 0.7 3.458000e-07 0.7 3.458100e-07 0 3.492000e-07 0
+ 3.492100e-07 0.7 3.494000e-07 0.7 3.494100e-07 0 3.496000e-07 0 3.496100e-07 0.7 3.498000e-07 0.7
+ 3.498100e-07 0 3.532000e-07 0 3.532100e-07 0.7 3.534000e-07 0.7 3.534100e-07 0 3.536000e-07 0
+ 3.536100e-07 0.7 3.538000e-07 0.7 3.538100e-07 0 3.572000e-07 0 3.572100e-07 0.7 3.574000e-07 0.7
+ 3.574100e-07 0 3.576000e-07 0 3.576100e-07 0.7 3.578000e-07 0.7 3.578100e-07 0 3.612000e-07 0
+ 3.612100e-07 0.7 3.614000e-07 0.7 3.614100e-07 0 3.616000e-07 0 3.616100e-07 0.7 3.618000e-07 0.7
+ 3.618100e-07 0 3.652000e-07 0 3.652100e-07 0.7 3.654000e-07 0.7 3.654100e-07 0 3.656000e-07 0
+ 3.656100e-07 0.7 3.658000e-07 0.7 3.658100e-07 0 3.692000e-07 0 3.692100e-07 0.7 3.694000e-07 0.7
+ 3.694100e-07 0 3.696000e-07 0 3.696100e-07 0.7 3.698000e-07 0.7 3.698100e-07 0 3.732000e-07 0
+ 3.732100e-07 0.7 3.734000e-07 0.7 3.734100e-07 0 3.736000e-07 0 3.736100e-07 0.7 3.738000e-07 0.7
+ 3.738100e-07 0 3.772000e-07 0 3.772100e-07 0.7 3.774000e-07 0.7 3.774100e-07 0 3.776000e-07 0
+ 3.776100e-07 0.7 3.778000e-07 0.7 3.778100e-07 0 3.812000e-07 0 3.812100e-07 0.7 3.814000e-07 0.7
+ 3.814100e-07 0 3.816000e-07 0 3.816100e-07 0.7 3.818000e-07 0.7 3.818100e-07 0 3.852000e-07 0
+ 3.852100e-07 0.7 3.854000e-07 0.7 3.854100e-07 0 3.856000e-07 0 3.856100e-07 0.7 3.858000e-07 0.7
+ 3.858100e-07 0 3.892000e-07 0 3.892100e-07 0.7 3.894000e-07 0.7 3.894100e-07 0 3.896000e-07 0
+ 3.896100e-07 0.7 3.898000e-07 0.7 3.898100e-07 0 3.932000e-07 0 3.932100e-07 0.7 3.934000e-07 0.7
+ 3.934100e-07 0 3.936000e-07 0 3.936100e-07 0.7 3.938000e-07 0.7 3.938100e-07 0 3.972000e-07 0
+ 3.972100e-07 0.7 3.974000e-07 0.7 3.974100e-07 0 3.976000e-07 0 3.976100e-07 0.7 3.978000e-07 0.7
+ 3.978100e-07 0 4.012000e-07 0 4.012100e-07 0.7 4.014000e-07 0.7 4.014100e-07 0 4.016000e-07 0
+ 4.016100e-07 0.7 4.018000e-07 0.7 4.018100e-07 0 4.052000e-07 0 4.052100e-07 0.7 4.054000e-07 0.7
+ 4.054100e-07 0 4.056000e-07 0 4.056100e-07 0.7 4.058000e-07 0.7 4.058100e-07 0 4.092000e-07 0
+ 4.092100e-07 0.7 4.094000e-07 0.7 4.094100e-07 0 4.096000e-07 0 4.096100e-07 0.7 4.098000e-07 0.7
+ 4.098100e-07 0 4.132000e-07 0 4.132100e-07 0.7 4.134000e-07 0.7 4.134100e-07 0 4.136000e-07 0
+ 4.136100e-07 0.7 4.138000e-07 0.7 4.138100e-07 0 4.172000e-07 0 4.172100e-07 0.7 4.174000e-07 0.7
+ 4.174100e-07 0 4.176000e-07 0 4.176100e-07 0.7 4.178000e-07 0.7 4.178100e-07 0 4.212000e-07 0
+ 4.212100e-07 0.7 4.214000e-07 0.7 4.214100e-07 0 4.216000e-07 0 4.216100e-07 0.7 4.218000e-07 0.7
+ 4.218100e-07 0 4.252000e-07 0 4.252100e-07 0.7 4.254000e-07 0.7 4.254100e-07 0 4.256000e-07 0
+ 4.256100e-07 0.7 4.258000e-07 0.7 4.258100e-07 0 4.292000e-07 0 4.292100e-07 0.7 4.294000e-07 0.7
+ 4.294100e-07 0 4.296000e-07 0 4.296100e-07 0.7 4.298000e-07 0.7 4.298100e-07 0 4.322000e-07 0
+ 4.322100e-07 0.7 4.332000e-07 0.7 4.332100e-07 0 4.334000e-07 0 4.334100e-07 0.7 4.372000e-07 0.7
+ 4.372100e-07 0 4.374000e-07 0 4.374100e-07 0.7 4.412000e-07 0.7 4.412100e-07 0 4.414000e-07 0
+ 4.414100e-07 0.7 4.452000e-07 0.7 4.452100e-07 0 4.454000e-07 0 4.454100e-07 0.7 4.492000e-07 0.7
+ 4.492100e-07 0 4.494000e-07 0 4.494100e-07 0.7 4.532000e-07 0.7 4.532100e-07 0 4.534000e-07 0
+ 4.534100e-07 0.7 4.572000e-07 0.7 4.572100e-07 0 4.574000e-07 0 4.574100e-07 0.7 4.612000e-07 0.7
+ 4.612100e-07 0 4.614000e-07 0 4.614100e-07 0.7 4.652000e-07 0.7 4.652100e-07 0 4.654000e-07 0
+ 4.654100e-07 0.7 4.692000e-07 0.7 4.692100e-07 0 4.694000e-07 0 4.694100e-07 0.7 4.732000e-07 0.7
+ 4.732100e-07 0 4.734000e-07 0 4.734100e-07 0.7 4.772000e-07 0.7 4.772100e-07 0 4.774000e-07 0
+ 4.774100e-07 0.7 4.812000e-07 0.7 4.812100e-07 0 4.814000e-07 0 4.814100e-07 0.7 4.852000e-07 0.7
+ 4.852100e-07 0 4.854000e-07 0 4.854100e-07 0.7 4.892000e-07 0.7 4.892100e-07 0 4.894000e-07 0
+ 4.894100e-07 0.7 4.932000e-07 0.7 4.932100e-07 0 4.934000e-07 0 4.934100e-07 0.7 4.972000e-07 0.7
+ 4.972100e-07 0 4.974000e-07 0 4.974100e-07 0.7 5.012000e-07 0.7 5.012100e-07 0 5.014000e-07 0
+ 5.014100e-07 0.7 5.052000e-07 0.7 5.052100e-07 0 5.054000e-07 0 5.054100e-07 0.7 5.092000e-07 0.7
+ 5.092100e-07 0 5.094000e-07 0 5.094100e-07 0.7 5.132000e-07 0.7 5.132100e-07 0 5.134000e-07 0
+ 5.134100e-07 0.7 5.172000e-07 0.7 5.172100e-07 0 5.174000e-07 0 5.174100e-07 0.7 5.212000e-07 0.7
+ 5.212100e-07 0 5.214000e-07 0 5.214100e-07 0.7 5.252000e-07 0.7 5.252100e-07 0 5.254000e-07 0
+ 5.254100e-07 0.7 5.292000e-07 0.7 5.292100e-07 0 5.294000e-07 0 5.294100e-07 0.7 5.332000e-07 0.7
+ 5.332100e-07 0 5.334000e-07 0 5.334100e-07 0.7 5.372000e-07 0.7 5.372100e-07 0 5.374000e-07 0
+ 5.374100e-07 0.7 5.412000e-07 0.7 5.412100e-07 0 5.414000e-07 0 5.414100e-07 0.7 5.452000e-07 0.7
+ 5.452100e-07 0 5.454000e-07 0 5.454100e-07 0.7 5.492000e-07 0.7 5.492100e-07 0 5.494000e-07 0
+ 5.494100e-07 0.7 5.532000e-07 0.7 5.532100e-07 0 5.534000e-07 0 5.534100e-07 0.7 5.572000e-07 0.7
+ 5.572100e-07 0 5.574000e-07 0 5.574100e-07 0.7 5.612000e-07 0.7 5.612100e-07 0 5.614000e-07 0
+ 5.614100e-07 0.7 5.652000e-07 0.7 5.652100e-07 0 5.654000e-07 0 5.654100e-07 0.7 5.692000e-07 0.7
+ 5.692100e-07 0 5.694000e-07 0 5.694100e-07 0.7 5.732000e-07 0.7 5.732100e-07 0 5.734000e-07 0
+ 5.734100e-07 0.7 5.772000e-07 0.7 5.772100e-07 0 5.774000e-07 0 5.774100e-07 0.7 5.812000e-07 0.7
+ 5.812100e-07 0 5.814000e-07 0 5.814100e-07 0.7 5.852000e-07 0.7 5.852100e-07 0 5.854000e-07 0
+ 5.854100e-07 0.7 5.892000e-07 0.7 5.892100e-07 0 5.894000e-07 0 5.894100e-07 0.7 5.932000e-07 0.7
+ 5.932100e-07 0 5.934000e-07 0 5.934100e-07 0.7 5.972000e-07 0.7 5.972100e-07 0 5.974000e-07 0
+ 5.974100e-07 0.7 6.012000e-07 0.7 6.012100e-07 0 6.014000e-07 0 6.014100e-07 0.7 6.052000e-07 0.7
+ 6.052100e-07 0 6.054000e-07 0 6.054100e-07 0.7 6.092000e-07 0.7 6.092100e-07 0 6.094000e-07 0
+ 6.094100e-07 0.7 6.132000e-07 0.7 6.132100e-07 0 6.134000e-07 0 6.134100e-07 0.7 6.172000e-07 0.7
+ 6.172100e-07 0 6.174000e-07 0 6.174100e-07 0.7 6.212000e-07 0.7 6.212100e-07 0 6.214000e-07 0
+ 6.214100e-07 0.7 6.252000e-07 0.7 6.252100e-07 0 6.254000e-07 0 6.254100e-07 0.7 6.292000e-07 0.7
+ 6.292100e-07 0 6.294000e-07 0 6.294100e-07 0.7 6.332000e-07 0.7 6.332100e-07 0 6.334000e-07 0
+ 6.334100e-07 0.7 6.372000e-07 0.7 6.372100e-07 0 6.374000e-07 0 6.374100e-07 0.7 6.412000e-07 0.7
+ 6.412100e-07 0 6.414000e-07 0 6.414100e-07 0.7 6.452000e-07 0.7 6.452100e-07 0 6.454000e-07 0
+ 6.454100e-07 0.7 6.482000e-07 0.7 6.482100e-07 0 6.492000e-07 0 6.492100e-07 0.7 6.494000e-07 0.7
+ 6.494100e-07 0 6.496000e-07 0 6.496100e-07 0.7 6.498000e-07 0.7 6.498100e-07 0 6.532000e-07 0
+ 6.532100e-07 0.7 6.534000e-07 0.7 6.534100e-07 0 6.536000e-07 0 6.536100e-07 0.7 6.538000e-07 0.7
+ 6.538100e-07 0 6.572000e-07 0 6.572100e-07 0.7 6.574000e-07 0.7 6.574100e-07 0 6.576000e-07 0
+ 6.576100e-07 0.7 6.578000e-07 0.7 6.578100e-07 0 6.612000e-07 0 6.612100e-07 0.7 6.614000e-07 0.7
+ 6.614100e-07 0 6.616000e-07 0 6.616100e-07 0.7 6.618000e-07 0.7 6.618100e-07 0 6.652000e-07 0
+ 6.652100e-07 0.7 6.654000e-07 0.7 6.654100e-07 0 6.656000e-07 0 6.656100e-07 0.7 6.658000e-07 0.7
+ 6.658100e-07 0 6.692000e-07 0 6.692100e-07 0.7 6.694000e-07 0.7 6.694100e-07 0 6.696000e-07 0
+ 6.696100e-07 0.7 6.698000e-07 0.7 6.698100e-07 0 6.732000e-07 0 6.732100e-07 0.7 6.734000e-07 0.7
+ 6.734100e-07 0 6.736000e-07 0 6.736100e-07 0.7 6.738000e-07 0.7 6.738100e-07 0 6.772000e-07 0
+ 6.772100e-07 0.7 6.774000e-07 0.7 6.774100e-07 0 6.776000e-07 0 6.776100e-07 0.7 6.778000e-07 0.7
+ 6.778100e-07 0 6.812000e-07 0 6.812100e-07 0.7 6.814000e-07 0.7 6.814100e-07 0 6.816000e-07 0
+ 6.816100e-07 0.7 6.818000e-07 0.7 6.818100e-07 0 6.852000e-07 0 6.852100e-07 0.7 6.854000e-07 0.7
+ 6.854100e-07 0 6.856000e-07 0 6.856100e-07 0.7 6.858000e-07 0.7 6.858100e-07 0 6.892000e-07 0
+ 6.892100e-07 0.7 6.894000e-07 0.7 6.894100e-07 0 6.896000e-07 0 6.896100e-07 0.7 6.898000e-07 0.7
+ 6.898100e-07 0 6.932000e-07 0 6.932100e-07 0.7 6.934000e-07 0.7 6.934100e-07 0 6.936000e-07 0
+ 6.936100e-07 0.7 6.938000e-07 0.7 6.938100e-07 0 6.972000e-07 0 6.972100e-07 0.7 6.974000e-07 0.7
+ 6.974100e-07 0 6.976000e-07 0 6.976100e-07 0.7 6.978000e-07 0.7 6.978100e-07 0 7.012000e-07 0
+ 7.012100e-07 0.7 7.014000e-07 0.7 7.014100e-07 0 7.016000e-07 0 7.016100e-07 0.7 7.018000e-07 0.7
+ 7.018100e-07 0 7.052000e-07 0 7.052100e-07 0.7 7.054000e-07 0.7 7.054100e-07 0 7.056000e-07 0
+ 7.056100e-07 0.7 7.058000e-07 0.7 7.058100e-07 0 7.092000e-07 0 7.092100e-07 0.7 7.094000e-07 0.7
+ 7.094100e-07 0 7.096000e-07 0 7.096100e-07 0.7 7.098000e-07 0.7 7.098100e-07 0 7.132000e-07 0
+ 7.132100e-07 0.7 7.134000e-07 0.7 7.134100e-07 0 7.136000e-07 0 7.136100e-07 0.7 7.138000e-07 0.7
+ 7.138100e-07 0 7.172000e-07 0 7.172100e-07 0.7 7.174000e-07 0.7 7.174100e-07 0 7.176000e-07 0
+ 7.176100e-07 0.7 7.178000e-07 0.7 7.178100e-07 0 7.212000e-07 0 7.212100e-07 0.7 7.214000e-07 0.7
+ 7.214100e-07 0 7.216000e-07 0 7.216100e-07 0.7 7.218000e-07 0.7 7.218100e-07 0 7.252000e-07 0
+ 7.252100e-07 0.7 7.254000e-07 0.7 7.254100e-07 0 7.256000e-07 0 7.256100e-07 0.7 7.258000e-07 0.7
+ 7.258100e-07 0 7.292000e-07 0 7.292100e-07 0.7 7.294000e-07 0.7 7.294100e-07 0 7.296000e-07 0
+ 7.296100e-07 0.7 7.298000e-07 0.7 7.298100e-07 0 7.332000e-07 0 7.332100e-07 0.7 7.334000e-07 0.7
+ 7.334100e-07 0 7.336000e-07 0 7.336100e-07 0.7 7.338000e-07 0.7 7.338100e-07 0 7.372000e-07 0
+ 7.372100e-07 0.7 7.374000e-07 0.7 7.374100e-07 0 7.376000e-07 0 7.376100e-07 0.7 7.378000e-07 0.7
+ 7.378100e-07 0 7.412000e-07 0 7.412100e-07 0.7 7.414000e-07 0.7 7.414100e-07 0 7.416000e-07 0
+ 7.416100e-07 0.7 7.418000e-07 0.7 7.418100e-07 0 7.452000e-07 0 7.452100e-07 0.7 7.454000e-07 0.7
+ 7.454100e-07 0 7.456000e-07 0 7.456100e-07 0.7 7.458000e-07 0.7 7.458100e-07 0 7.492000e-07 0
+ 7.492100e-07 0.7 7.494000e-07 0.7 7.494100e-07 0 7.496000e-07 0 7.496100e-07 0.7 7.498000e-07 0.7
+ 7.498100e-07 0 7.532000e-07 0 7.532100e-07 0.7 7.534000e-07 0.7 7.534100e-07 0 7.536000e-07 0
+ 7.536100e-07 0.7 7.538000e-07 0.7 7.538100e-07 0 7.562000e-07 0 7.562100e-07 0.7 7.572000e-07 0.7
+ 7.572100e-07 0 7.574000e-07 0 7.574100e-07 0.7 7.612000e-07 0.7 7.612100e-07 0 7.614000e-07 0
+ 7.614100e-07 0.7 7.652000e-07 0.7 7.652100e-07 0 7.654000e-07 0 7.654100e-07 0.7 7.692000e-07 0.7
+ 7.692100e-07 0 7.694000e-07 0 7.694100e-07 0.7 7.732000e-07 0.7 7.732100e-07 0 7.734000e-07 0
+ 7.734100e-07 0.7 7.772000e-07 0.7 7.772100e-07 0 7.774000e-07 0 7.774100e-07 0.7 7.812000e-07 0.7
+ 7.812100e-07 0 7.814000e-07 0 7.814100e-07 0.7 7.852000e-07 0.7 7.852100e-07 0 7.854000e-07 0
+ 7.854100e-07 0.7 7.892000e-07 0.7 7.892100e-07 0 7.894000e-07 0 7.894100e-07 0.7 7.932000e-07 0.7
+ 7.932100e-07 0 7.934000e-07 0 7.934100e-07 0.7 7.972000e-07 0.7 7.972100e-07 0 7.974000e-07 0
+ 7.974100e-07 0.7 8.012000e-07 0.7 8.012100e-07 0 8.014000e-07 0 8.014100e-07 0.7 8.052000e-07 0.7
+ 8.052100e-07 0 8.054000e-07 0 8.054100e-07 0.7 8.092000e-07 0.7 8.092100e-07 0 8.094000e-07 0
+ 8.094100e-07 0.7 8.132000e-07 0.7 8.132100e-07 0 8.134000e-07 0 8.134100e-07 0.7 8.172000e-07 0.7
+ 8.172100e-07 0 8.174000e-07 0 8.174100e-07 0.7 8.212000e-07 0.7 8.212100e-07 0 8.214000e-07 0
+ 8.214100e-07 0.7 8.252000e-07 0.7 8.252100e-07 0 8.254000e-07 0 8.254100e-07 0.7 8.292000e-07 0.7
+ 8.292100e-07 0 8.294000e-07 0 8.294100e-07 0.7 8.332000e-07 0.7 8.332100e-07 0 8.334000e-07 0
+ 8.334100e-07 0.7 8.372000e-07 0.7 8.372100e-07 0 8.374000e-07 0 8.374100e-07 0.7 8.412000e-07 0.7
+ 8.412100e-07 0 8.414000e-07 0 8.414100e-07 0.7 8.452000e-07 0.7 8.452100e-07 0 8.454000e-07 0
+ 8.454100e-07 0.7 8.492000e-07 0.7 8.492100e-07 0 8.494000e-07 0 8.494100e-07 0.7 8.532000e-07 0.7
+ 8.532100e-07 0 8.534000e-07 0 8.534100e-07 0.7 8.572000e-07 0.7 8.572100e-07 0 8.574000e-07 0
+ 8.574100e-07 0.7 8.612000e-07 0.7 8.612100e-07 0 8.614000e-07 0 8.614100e-07 0.7 8.652000e-07 0.7
+ 8.652100e-07 0 8.654000e-07 0 8.654100e-07 0.7 8.692000e-07 0.7 8.692100e-07 0 8.694000e-07 0
+ 8.694100e-07 0.7 8.732000e-07 0.7 8.732100e-07 0 8.734000e-07 0 8.734100e-07 0.7 8.772000e-07 0.7
+ 8.772100e-07 0 8.774000e-07 0 8.774100e-07 0.7 8.812000e-07 0.7 8.812100e-07 0 8.814000e-07 0
+ 8.814100e-07 0.7 8.852000e-07 0.7 8.852100e-07 0 8.854000e-07 0 8.854100e-07 0.7 8.892000e-07 0.7
+ 8.892100e-07 0 8.894000e-07 0 8.894100e-07 0.7 8.932000e-07 0.7 8.932100e-07 0 8.934000e-07 0
+ 8.934100e-07 0.7 8.972000e-07 0.7 8.972100e-07 0 8.974000e-07 0 8.974100e-07 0.7 9.012000e-07 0.7
+ 9.012100e-07 0 9.014000e-07 0 9.014100e-07 0.7 9.052000e-07 0.7 9.052100e-07 0 9.054000e-07 0
+ 9.054100e-07 0.7 9.092000e-07 0.7 9.092100e-07 0 9.094000e-07 0 9.094100e-07 0.7 9.132000e-07 0.7
+ 9.132100e-07 0 9.134000e-07 0 9.134100e-07 0.7 9.172000e-07 0.7 9.172100e-07 0 9.174000e-07 0
+ 9.174100e-07 0.7 9.212000e-07 0.7 9.212100e-07 0 9.214000e-07 0 9.214100e-07 0.7 9.252000e-07 0.7
+ 9.252100e-07 0 9.254000e-07 0 9.254100e-07 0.7 9.292000e-07 0.7 9.292100e-07 0 9.294000e-07 0
+ 9.294100e-07 0.7 9.332000e-07 0.7 9.332100e-07 0 9.334000e-07 0 9.334100e-07 0.7 9.372000e-07 0.7
+ 9.372100e-07 0 9.374000e-07 0 9.374100e-07 0.7 9.412000e-07 0.7 9.412100e-07 0 9.414000e-07 0
+ 9.414100e-07 0.7 9.452000e-07 0.7 9.452100e-07 0 9.454000e-07 0 9.454100e-07 0.7 9.492000e-07 0.7
+ 9.492100e-07 0 9.494000e-07 0 9.494100e-07 0.7 9.532000e-07 0.7 9.532100e-07 0 9.534000e-07 0
+ 9.534100e-07 0.7 9.572000e-07 0.7 9.572100e-07 0 9.574000e-07 0 9.574100e-07 0.7 9.612000e-07 0.7
+ 9.612100e-07 0 9.614000e-07 0 9.614100e-07 0.7 9.652000e-07 0.7 9.652100e-07 0 9.654000e-07 0
+ 9.654100e-07 0.7 9.692000e-07 0.7 9.692100e-07 0 9.694000e-07 0 9.694100e-07 0.7 )
v_WA1 src_WA1 0 pwl(
+ 0.000000e+00 0 1.600000e-09 0 1.610000e-09 0.7 1.800000e-09 0.7 1.810000e-09 0 5.600000e-09 0
+ 5.610000e-09 0.7 5.800000e-09 0.7 5.810000e-09 0 9.600000e-09 0 9.610000e-09 0.7 9.800000e-09 0.7
+ 9.810000e-09 0 1.360000e-08 0 1.361000e-08 0.7 1.380000e-08 0.7 1.381000e-08 0 1.760000e-08 0
+ 1.761000e-08 0.7 1.780000e-08 0.7 1.781000e-08 0 2.160000e-08 0 2.161000e-08 0.7 2.180000e-08 0.7
+ 2.181000e-08 0 2.560000e-08 0 2.561000e-08 0.7 2.580000e-08 0.7 2.581000e-08 0 2.960000e-08 0
+ 2.961000e-08 0.7 2.980000e-08 0.7 2.981000e-08 0 3.360000e-08 0 3.361000e-08 0.7 3.380000e-08 0.7
+ 3.381000e-08 0 3.760000e-08 0 3.761000e-08 0.7 3.780000e-08 0.7 3.781000e-08 0 4.160000e-08 0
+ 4.161000e-08 0.7 4.180000e-08 0.7 4.181000e-08 0 4.560000e-08 0 4.561000e-08 0.7 4.580000e-08 0.7
+ 4.581000e-08 0 4.960000e-08 0 4.961000e-08 0.7 4.980000e-08 0.7 4.981000e-08 0 5.360000e-08 0
+ 5.361000e-08 0.7 5.380000e-08 0.7 5.381000e-08 0 5.760000e-08 0 5.761000e-08 0.7 5.780000e-08 0.7
+ 5.781000e-08 0 6.160000e-08 0 6.161000e-08 0.7 6.180000e-08 0.7 6.181000e-08 0 6.560000e-08 0
+ 6.561000e-08 0.7 6.580000e-08 0.7 6.581000e-08 0 6.960000e-08 0 6.961000e-08 0.7 6.980000e-08 0.7
+ 6.981000e-08 0 7.360000e-08 0 7.361000e-08 0.7 7.380000e-08 0.7 7.381000e-08 0 7.760000e-08 0
+ 7.761000e-08 0.7 7.780000e-08 0.7 7.781000e-08 0 8.160000e-08 0 8.161000e-08 0.7 8.180000e-08 0.7
+ 8.181000e-08 0 8.560000e-08 0 8.561000e-08 0.7 8.580000e-08 0.7 8.581000e-08 0 8.960000e-08 0
+ 8.961000e-08 0.7 8.980000e-08 0.7 8.981000e-08 0 9.360000e-08 0 9.361000e-08 0.7 9.380000e-08 0.7
+ 9.381000e-08 0 9.760000e-08 0 9.761000e-08 0.7 9.780000e-08 0.7 9.781000e-08 0 1.016000e-07 0
+ 1.016100e-07 0.7 1.018000e-07 0.7 1.018100e-07 0 1.056000e-07 0 1.056100e-07 0.7 1.058000e-07 0.7
+ 1.058100e-07 0 1.096000e-07 0 1.096100e-07 0.7 1.098000e-07 0.7 1.098100e-07 0 1.136000e-07 0
+ 1.136100e-07 0.7 1.138000e-07 0.7 1.138100e-07 0 1.176000e-07 0 1.176100e-07 0.7 1.178000e-07 0.7
+ 1.178100e-07 0 1.216000e-07 0 1.216100e-07 0.7 1.218000e-07 0.7 1.218100e-07 0 1.256000e-07 0
+ 1.256100e-07 0.7 1.258000e-07 0.7 1.258100e-07 0 1.296000e-07 0 1.296100e-07 0.7 1.298000e-07 0.7
+ 1.298100e-07 0 1.336000e-07 0 1.336100e-07 0.7 1.338000e-07 0.7 1.338100e-07 0 1.376000e-07 0
+ 1.376100e-07 0.7 1.378000e-07 0.7 1.378100e-07 0 1.416000e-07 0 1.416100e-07 0.7 1.418000e-07 0.7
+ 1.418100e-07 0 1.456000e-07 0 1.456100e-07 0.7 1.458000e-07 0.7 1.458100e-07 0 1.496000e-07 0
+ 1.496100e-07 0.7 1.498000e-07 0.7 1.498100e-07 0 1.536000e-07 0 1.536100e-07 0.7 1.538000e-07 0.7
+ 1.538100e-07 0 1.576000e-07 0 1.576100e-07 0.7 1.578000e-07 0.7 1.578100e-07 0 1.616000e-07 0
+ 1.616100e-07 0.7 1.618000e-07 0.7 1.618100e-07 0 1.656000e-07 0 1.656100e-07 0.7 1.658000e-07 0.7
+ 1.658100e-07 0 1.696000e-07 0 1.696100e-07 0.7 1.698000e-07 0.7 1.698100e-07 0 1.736000e-07 0
+ 1.736100e-07 0.7 1.738000e-07 0.7 1.738100e-07 0 1.776000e-07 0 1.776100e-07 0.7 1.778000e-07 0.7
+ 1.778100e-07 0 1.816000e-07 0 1.816100e-07 0.7 1.818000e-07 0.7 1.818100e-07 0 1.856000e-07 0
+ 1.856100e-07 0.7 1.858000e-07 0.7 1.858100e-07 0 1.896000e-07 0 1.896100e-07 0.7 1.898000e-07 0.7
+ 1.898100e-07 0 1.936000e-07 0 1.936100e-07 0.7 1.938000e-07 0.7 1.938100e-07 0 1.976000e-07 0
+ 1.976100e-07 0.7 1.978000e-07 0.7 1.978100e-07 0 2.016000e-07 0 2.016100e-07 0.7 2.018000e-07 0.7
+ 2.018100e-07 0 2.056000e-07 0 2.056100e-07 0.7 2.058000e-07 0.7 2.058100e-07 0 2.096000e-07 0
+ 2.096100e-07 0.7 2.098000e-07 0.7 2.098100e-07 0 2.136000e-07 0 2.136100e-07 0.7 2.138000e-07 0.7
+ 2.138100e-07 0 2.162000e-07 0 2.162100e-07 0.7 2.172000e-07 0.7 2.172100e-07 0 2.174000e-07 0
+ 2.174100e-07 0.7 2.176000e-07 0.7 2.176100e-07 0 2.178000e-07 0 2.178100e-07 0.7 2.212000e-07 0.7
+ 2.212100e-07 0 2.214000e-07 0 2.214100e-07 0.7 2.216000e-07 0.7 2.216100e-07 0 2.218000e-07 0
+ 2.218100e-07 0.7 2.252000e-07 0.7 2.252100e-07 0 2.254000e-07 0 2.254100e-07 0.7 2.256000e-07 0.7
+ 2.256100e-07 0 2.258000e-07 0 2.258100e-07 0.7 2.292000e-07 0.7 2.292100e-07 0 2.294000e-07 0
+ 2.294100e-07 0.7 2.296000e-07 0.7 2.296100e-07 0 2.298000e-07 0 2.298100e-07 0.7 2.332000e-07 0.7
+ 2.332100e-07 0 2.334000e-07 0 2.334100e-07 0.7 2.336000e-07 0.7 2.336100e-07 0 2.338000e-07 0
+ 2.338100e-07 0.7 2.372000e-07 0.7 2.372100e-07 0 2.374000e-07 0 2.374100e-07 0.7 2.376000e-07 0.7
+ 2.376100e-07 0 2.378000e-07 0 2.378100e-07 0.7 2.412000e-07 0.7 2.412100e-07 0 2.414000e-07 0
+ 2.414100e-07 0.7 2.416000e-07 0.7 2.416100e-07 0 2.418000e-07 0 2.418100e-07 0.7 2.452000e-07 0.7
+ 2.452100e-07 0 2.454000e-07 0 2.454100e-07 0.7 2.456000e-07 0.7 2.456100e-07 0 2.458000e-07 0
+ 2.458100e-07 0.7 2.492000e-07 0.7 2.492100e-07 0 2.494000e-07 0 2.494100e-07 0.7 2.496000e-07 0.7
+ 2.496100e-07 0 2.498000e-07 0 2.498100e-07 0.7 2.532000e-07 0.7 2.532100e-07 0 2.534000e-07 0
+ 2.534100e-07 0.7 2.536000e-07 0.7 2.536100e-07 0 2.538000e-07 0 2.538100e-07 0.7 2.572000e-07 0.7
+ 2.572100e-07 0 2.574000e-07 0 2.574100e-07 0.7 2.576000e-07 0.7 2.576100e-07 0 2.578000e-07 0
+ 2.578100e-07 0.7 2.612000e-07 0.7 2.612100e-07 0 2.614000e-07 0 2.614100e-07 0.7 2.616000e-07 0.7
+ 2.616100e-07 0 2.618000e-07 0 2.618100e-07 0.7 2.652000e-07 0.7 2.652100e-07 0 2.654000e-07 0
+ 2.654100e-07 0.7 2.656000e-07 0.7 2.656100e-07 0 2.658000e-07 0 2.658100e-07 0.7 2.692000e-07 0.7
+ 2.692100e-07 0 2.694000e-07 0 2.694100e-07 0.7 2.696000e-07 0.7 2.696100e-07 0 2.698000e-07 0
+ 2.698100e-07 0.7 2.732000e-07 0.7 2.732100e-07 0 2.734000e-07 0 2.734100e-07 0.7 2.736000e-07 0.7
+ 2.736100e-07 0 2.738000e-07 0 2.738100e-07 0.7 2.772000e-07 0.7 2.772100e-07 0 2.774000e-07 0
+ 2.774100e-07 0.7 2.776000e-07 0.7 2.776100e-07 0 2.778000e-07 0 2.778100e-07 0.7 2.812000e-07 0.7
+ 2.812100e-07 0 2.814000e-07 0 2.814100e-07 0.7 2.816000e-07 0.7 2.816100e-07 0 2.818000e-07 0
+ 2.818100e-07 0.7 2.852000e-07 0.7 2.852100e-07 0 2.854000e-07 0 2.854100e-07 0.7 2.856000e-07 0.7
+ 2.856100e-07 0 2.858000e-07 0 2.858100e-07 0.7 2.892000e-07 0.7 2.892100e-07 0 2.894000e-07 0
+ 2.894100e-07 0.7 2.896000e-07 0.7 2.896100e-07 0 2.898000e-07 0 2.898100e-07 0.7 2.932000e-07 0.7
+ 2.932100e-07 0 2.934000e-07 0 2.934100e-07 0.7 2.936000e-07 0.7 2.936100e-07 0 2.938000e-07 0
+ 2.938100e-07 0.7 2.972000e-07 0.7 2.972100e-07 0 2.974000e-07 0 2.974100e-07 0.7 2.976000e-07 0.7
+ 2.976100e-07 0 2.978000e-07 0 2.978100e-07 0.7 3.012000e-07 0.7 3.012100e-07 0 3.014000e-07 0
+ 3.014100e-07 0.7 3.016000e-07 0.7 3.016100e-07 0 3.018000e-07 0 3.018100e-07 0.7 3.052000e-07 0.7
+ 3.052100e-07 0 3.054000e-07 0 3.054100e-07 0.7 3.056000e-07 0.7 3.056100e-07 0 3.058000e-07 0
+ 3.058100e-07 0.7 3.092000e-07 0.7 3.092100e-07 0 3.094000e-07 0 3.094100e-07 0.7 3.096000e-07 0.7
+ 3.096100e-07 0 3.098000e-07 0 3.098100e-07 0.7 3.132000e-07 0.7 3.132100e-07 0 3.134000e-07 0
+ 3.134100e-07 0.7 3.136000e-07 0.7 3.136100e-07 0 3.138000e-07 0 3.138100e-07 0.7 3.172000e-07 0.7
+ 3.172100e-07 0 3.174000e-07 0 3.174100e-07 0.7 3.176000e-07 0.7 3.176100e-07 0 3.178000e-07 0
+ 3.178100e-07 0.7 3.212000e-07 0.7 3.212100e-07 0 3.214000e-07 0 3.214100e-07 0.7 3.216000e-07 0.7
+ 3.216100e-07 0 3.218000e-07 0 3.218100e-07 0.7 3.242000e-07 0.7 3.242100e-07 0 3.256000e-07 0
+ 3.256100e-07 0.7 3.258000e-07 0.7 3.258100e-07 0 3.296000e-07 0 3.296100e-07 0.7 3.298000e-07 0.7
+ 3.298100e-07 0 3.336000e-07 0 3.336100e-07 0.7 3.338000e-07 0.7 3.338100e-07 0 3.376000e-07 0
+ 3.376100e-07 0.7 3.378000e-07 0.7 3.378100e-07 0 3.416000e-07 0 3.416100e-07 0.7 3.418000e-07 0.7
+ 3.418100e-07 0 3.456000e-07 0 3.456100e-07 0.7 3.458000e-07 0.7 3.458100e-07 0 3.496000e-07 0
+ 3.496100e-07 0.7 3.498000e-07 0.7 3.498100e-07 0 3.536000e-07 0 3.536100e-07 0.7 3.538000e-07 0.7
+ 3.538100e-07 0 3.576000e-07 0 3.576100e-07 0.7 3.578000e-07 0.7 3.578100e-07 0 3.616000e-07 0
+ 3.616100e-07 0.7 3.618000e-07 0.7 3.618100e-07 0 3.656000e-07 0 3.656100e-07 0.7 3.658000e-07 0.7
+ 3.658100e-07 0 3.696000e-07 0 3.696100e-07 0.7 3.698000e-07 0.7 3.698100e-07 0 3.736000e-07 0
+ 3.736100e-07 0.7 3.738000e-07 0.7 3.738100e-07 0 3.776000e-07 0 3.776100e-07 0.7 3.778000e-07 0.7
+ 3.778100e-07 0 3.816000e-07 0 3.816100e-07 0.7 3.818000e-07 0.7 3.818100e-07 0 3.856000e-07 0
+ 3.856100e-07 0.7 3.858000e-07 0.7 3.858100e-07 0 3.896000e-07 0 3.896100e-07 0.7 3.898000e-07 0.7
+ 3.898100e-07 0 3.936000e-07 0 3.936100e-07 0.7 3.938000e-07 0.7 3.938100e-07 0 3.976000e-07 0
+ 3.976100e-07 0.7 3.978000e-07 0.7 3.978100e-07 0 4.016000e-07 0 4.016100e-07 0.7 4.018000e-07 0.7
+ 4.018100e-07 0 4.056000e-07 0 4.056100e-07 0.7 4.058000e-07 0.7 4.058100e-07 0 4.096000e-07 0
+ 4.096100e-07 0.7 4.098000e-07 0.7 4.098100e-07 0 4.136000e-07 0 4.136100e-07 0.7 4.138000e-07 0.7
+ 4.138100e-07 0 4.176000e-07 0 4.176100e-07 0.7 4.178000e-07 0.7 4.178100e-07 0 4.216000e-07 0
+ 4.216100e-07 0.7 4.218000e-07 0.7 4.218100e-07 0 4.256000e-07 0 4.256100e-07 0.7 4.258000e-07 0.7
+ 4.258100e-07 0 4.296000e-07 0 4.296100e-07 0.7 4.298000e-07 0.7 4.298100e-07 0 4.336000e-07 0
+ 4.336100e-07 0.7 4.338000e-07 0.7 4.338100e-07 0 4.376000e-07 0 4.376100e-07 0.7 4.378000e-07 0.7
+ 4.378100e-07 0 4.416000e-07 0 4.416100e-07 0.7 4.418000e-07 0.7 4.418100e-07 0 4.456000e-07 0
+ 4.456100e-07 0.7 4.458000e-07 0.7 4.458100e-07 0 4.496000e-07 0 4.496100e-07 0.7 4.498000e-07 0.7
+ 4.498100e-07 0 4.536000e-07 0 4.536100e-07 0.7 4.538000e-07 0.7 4.538100e-07 0 4.576000e-07 0
+ 4.576100e-07 0.7 4.578000e-07 0.7 4.578100e-07 0 4.616000e-07 0 4.616100e-07 0.7 4.618000e-07 0.7
+ 4.618100e-07 0 4.656000e-07 0 4.656100e-07 0.7 4.658000e-07 0.7 4.658100e-07 0 4.696000e-07 0
+ 4.696100e-07 0.7 4.698000e-07 0.7 4.698100e-07 0 4.736000e-07 0 4.736100e-07 0.7 4.738000e-07 0.7
+ 4.738100e-07 0 4.776000e-07 0 4.776100e-07 0.7 4.778000e-07 0.7 4.778100e-07 0 4.816000e-07 0
+ 4.816100e-07 0.7 4.818000e-07 0.7 4.818100e-07 0 4.856000e-07 0 4.856100e-07 0.7 4.858000e-07 0.7
+ 4.858100e-07 0 4.896000e-07 0 4.896100e-07 0.7 4.898000e-07 0.7 4.898100e-07 0 4.936000e-07 0
+ 4.936100e-07 0.7 4.938000e-07 0.7 4.938100e-07 0 4.976000e-07 0 4.976100e-07 0.7 4.978000e-07 0.7
+ 4.978100e-07 0 5.016000e-07 0 5.016100e-07 0.7 5.018000e-07 0.7 5.018100e-07 0 5.056000e-07 0
+ 5.056100e-07 0.7 5.058000e-07 0.7 5.058100e-07 0 5.096000e-07 0 5.096100e-07 0.7 5.098000e-07 0.7
+ 5.098100e-07 0 5.136000e-07 0 5.136100e-07 0.7 5.138000e-07 0.7 5.138100e-07 0 5.176000e-07 0
+ 5.176100e-07 0.7 5.178000e-07 0.7 5.178100e-07 0 5.216000e-07 0 5.216100e-07 0.7 5.218000e-07 0.7
+ 5.218100e-07 0 5.256000e-07 0 5.256100e-07 0.7 5.258000e-07 0.7 5.258100e-07 0 5.296000e-07 0
+ 5.296100e-07 0.7 5.298000e-07 0.7 5.298100e-07 0 5.336000e-07 0 5.336100e-07 0.7 5.338000e-07 0.7
+ 5.338100e-07 0 5.376000e-07 0 5.376100e-07 0.7 5.378000e-07 0.7 5.378100e-07 0 5.402000e-07 0
+ 5.402100e-07 0.7 5.412000e-07 0.7 5.412100e-07 0 5.414000e-07 0 5.414100e-07 0.7 5.416000e-07 0.7
+ 5.416100e-07 0 5.418000e-07 0 5.418100e-07 0.7 5.452000e-07 0.7 5.452100e-07 0 5.454000e-07 0
+ 5.454100e-07 0.7 5.456000e-07 0.7 5.456100e-07 0 5.458000e-07 0 5.458100e-07 0.7 5.492000e-07 0.7
+ 5.492100e-07 0 5.494000e-07 0 5.494100e-07 0.7 5.496000e-07 0.7 5.496100e-07 0 5.498000e-07 0
+ 5.498100e-07 0.7 5.532000e-07 0.7 5.532100e-07 0 5.534000e-07 0 5.534100e-07 0.7 5.536000e-07 0.7
+ 5.536100e-07 0 5.538000e-07 0 5.538100e-07 0.7 5.572000e-07 0.7 5.572100e-07 0 5.574000e-07 0
+ 5.574100e-07 0.7 5.576000e-07 0.7 5.576100e-07 0 5.578000e-07 0 5.578100e-07 0.7 5.612000e-07 0.7
+ 5.612100e-07 0 5.614000e-07 0 5.614100e-07 0.7 5.616000e-07 0.7 5.616100e-07 0 5.618000e-07 0
+ 5.618100e-07 0.7 5.652000e-07 0.7 5.652100e-07 0 5.654000e-07 0 5.654100e-07 0.7 5.656000e-07 0.7
+ 5.656100e-07 0 5.658000e-07 0 5.658100e-07 0.7 5.692000e-07 0.7 5.692100e-07 0 5.694000e-07 0
+ 5.694100e-07 0.7 5.696000e-07 0.7 5.696100e-07 0 5.698000e-07 0 5.698100e-07 0.7 5.732000e-07 0.7
+ 5.732100e-07 0 5.734000e-07 0 5.734100e-07 0.7 5.736000e-07 0.7 5.736100e-07 0 5.738000e-07 0
+ 5.738100e-07 0.7 5.772000e-07 0.7 5.772100e-07 0 5.774000e-07 0 5.774100e-07 0.7 5.776000e-07 0.7
+ 5.776100e-07 0 5.778000e-07 0 5.778100e-07 0.7 5.812000e-07 0.7 5.812100e-07 0 5.814000e-07 0
+ 5.814100e-07 0.7 5.816000e-07 0.7 5.816100e-07 0 5.818000e-07 0 5.818100e-07 0.7 5.852000e-07 0.7
+ 5.852100e-07 0 5.854000e-07 0 5.854100e-07 0.7 5.856000e-07 0.7 5.856100e-07 0 5.858000e-07 0
+ 5.858100e-07 0.7 5.892000e-07 0.7 5.892100e-07 0 5.894000e-07 0 5.894100e-07 0.7 5.896000e-07 0.7
+ 5.896100e-07 0 5.898000e-07 0 5.898100e-07 0.7 5.932000e-07 0.7 5.932100e-07 0 5.934000e-07 0
+ 5.934100e-07 0.7 5.936000e-07 0.7 5.936100e-07 0 5.938000e-07 0 5.938100e-07 0.7 5.972000e-07 0.7
+ 5.972100e-07 0 5.974000e-07 0 5.974100e-07 0.7 5.976000e-07 0.7 5.976100e-07 0 5.978000e-07 0
+ 5.978100e-07 0.7 6.012000e-07 0.7 6.012100e-07 0 6.014000e-07 0 6.014100e-07 0.7 6.016000e-07 0.7
+ 6.016100e-07 0 6.018000e-07 0 6.018100e-07 0.7 6.052000e-07 0.7 6.052100e-07 0 6.054000e-07 0
+ 6.054100e-07 0.7 6.056000e-07 0.7 6.056100e-07 0 6.058000e-07 0 6.058100e-07 0.7 6.092000e-07 0.7
+ 6.092100e-07 0 6.094000e-07 0 6.094100e-07 0.7 6.096000e-07 0.7 6.096100e-07 0 6.098000e-07 0
+ 6.098100e-07 0.7 6.132000e-07 0.7 6.132100e-07 0 6.134000e-07 0 6.134100e-07 0.7 6.136000e-07 0.7
+ 6.136100e-07 0 6.138000e-07 0 6.138100e-07 0.7 6.172000e-07 0.7 6.172100e-07 0 6.174000e-07 0
+ 6.174100e-07 0.7 6.176000e-07 0.7 6.176100e-07 0 6.178000e-07 0 6.178100e-07 0.7 6.212000e-07 0.7
+ 6.212100e-07 0 6.214000e-07 0 6.214100e-07 0.7 6.216000e-07 0.7 6.216100e-07 0 6.218000e-07 0
+ 6.218100e-07 0.7 6.252000e-07 0.7 6.252100e-07 0 6.254000e-07 0 6.254100e-07 0.7 6.256000e-07 0.7
+ 6.256100e-07 0 6.258000e-07 0 6.258100e-07 0.7 6.292000e-07 0.7 6.292100e-07 0 6.294000e-07 0
+ 6.294100e-07 0.7 6.296000e-07 0.7 6.296100e-07 0 6.298000e-07 0 6.298100e-07 0.7 6.332000e-07 0.7
+ 6.332100e-07 0 6.334000e-07 0 6.334100e-07 0.7 6.336000e-07 0.7 6.336100e-07 0 6.338000e-07 0
+ 6.338100e-07 0.7 6.372000e-07 0.7 6.372100e-07 0 6.374000e-07 0 6.374100e-07 0.7 6.376000e-07 0.7
+ 6.376100e-07 0 6.378000e-07 0 6.378100e-07 0.7 6.412000e-07 0.7 6.412100e-07 0 6.414000e-07 0
+ 6.414100e-07 0.7 6.416000e-07 0.7 6.416100e-07 0 6.418000e-07 0 6.418100e-07 0.7 6.452000e-07 0.7
+ 6.452100e-07 0 6.454000e-07 0 6.454100e-07 0.7 6.456000e-07 0.7 6.456100e-07 0 6.458000e-07 0
+ 6.458100e-07 0.7 6.482000e-07 0.7 6.482100e-07 0 6.496000e-07 0 6.496100e-07 0.7 6.498000e-07 0.7
+ 6.498100e-07 0 6.536000e-07 0 6.536100e-07 0.7 6.538000e-07 0.7 6.538100e-07 0 6.576000e-07 0
+ 6.576100e-07 0.7 6.578000e-07 0.7 6.578100e-07 0 6.616000e-07 0 6.616100e-07 0.7 6.618000e-07 0.7
+ 6.618100e-07 0 6.656000e-07 0 6.656100e-07 0.7 6.658000e-07 0.7 6.658100e-07 0 6.696000e-07 0
+ 6.696100e-07 0.7 6.698000e-07 0.7 6.698100e-07 0 6.736000e-07 0 6.736100e-07 0.7 6.738000e-07 0.7
+ 6.738100e-07 0 6.776000e-07 0 6.776100e-07 0.7 6.778000e-07 0.7 6.778100e-07 0 6.816000e-07 0
+ 6.816100e-07 0.7 6.818000e-07 0.7 6.818100e-07 0 6.856000e-07 0 6.856100e-07 0.7 6.858000e-07 0.7
+ 6.858100e-07 0 6.896000e-07 0 6.896100e-07 0.7 6.898000e-07 0.7 6.898100e-07 0 6.936000e-07 0
+ 6.936100e-07 0.7 6.938000e-07 0.7 6.938100e-07 0 6.976000e-07 0 6.976100e-07 0.7 6.978000e-07 0.7
+ 6.978100e-07 0 7.016000e-07 0 7.016100e-07 0.7 7.018000e-07 0.7 7.018100e-07 0 7.056000e-07 0
+ 7.056100e-07 0.7 7.058000e-07 0.7 7.058100e-07 0 7.096000e-07 0 7.096100e-07 0.7 7.098000e-07 0.7
+ 7.098100e-07 0 7.136000e-07 0 7.136100e-07 0.7 7.138000e-07 0.7 7.138100e-07 0 7.176000e-07 0
+ 7.176100e-07 0.7 7.178000e-07 0.7 7.178100e-07 0 7.216000e-07 0 7.216100e-07 0.7 7.218000e-07 0.7
+ 7.218100e-07 0 7.256000e-07 0 7.256100e-07 0.7 7.258000e-07 0.7 7.258100e-07 0 7.296000e-07 0
+ 7.296100e-07 0.7 7.298000e-07 0.7 7.298100e-07 0 7.336000e-07 0 7.336100e-07 0.7 7.338000e-07 0.7
+ 7.338100e-07 0 7.376000e-07 0 7.376100e-07 0.7 7.378000e-07 0.7 7.378100e-07 0 7.416000e-07 0
+ 7.416100e-07 0.7 7.418000e-07 0.7 7.418100e-07 0 7.456000e-07 0 7.456100e-07 0.7 7.458000e-07 0.7
+ 7.458100e-07 0 7.496000e-07 0 7.496100e-07 0.7 7.498000e-07 0.7 7.498100e-07 0 7.536000e-07 0
+ 7.536100e-07 0.7 7.538000e-07 0.7 7.538100e-07 0 7.576000e-07 0 7.576100e-07 0.7 7.578000e-07 0.7
+ 7.578100e-07 0 7.616000e-07 0 7.616100e-07 0.7 7.618000e-07 0.7 7.618100e-07 0 7.656000e-07 0
+ 7.656100e-07 0.7 7.658000e-07 0.7 7.658100e-07 0 7.696000e-07 0 7.696100e-07 0.7 7.698000e-07 0.7
+ 7.698100e-07 0 7.736000e-07 0 7.736100e-07 0.7 7.738000e-07 0.7 7.738100e-07 0 7.776000e-07 0
+ 7.776100e-07 0.7 7.778000e-07 0.7 7.778100e-07 0 7.816000e-07 0 7.816100e-07 0.7 7.818000e-07 0.7
+ 7.818100e-07 0 7.856000e-07 0 7.856100e-07 0.7 7.858000e-07 0.7 7.858100e-07 0 7.896000e-07 0
+ 7.896100e-07 0.7 7.898000e-07 0.7 7.898100e-07 0 7.936000e-07 0 7.936100e-07 0.7 7.938000e-07 0.7
+ 7.938100e-07 0 7.976000e-07 0 7.976100e-07 0.7 7.978000e-07 0.7 7.978100e-07 0 8.016000e-07 0
+ 8.016100e-07 0.7 8.018000e-07 0.7 8.018100e-07 0 8.056000e-07 0 8.056100e-07 0.7 8.058000e-07 0.7
+ 8.058100e-07 0 8.096000e-07 0 8.096100e-07 0.7 8.098000e-07 0.7 8.098100e-07 0 8.136000e-07 0
+ 8.136100e-07 0.7 8.138000e-07 0.7 8.138100e-07 0 8.176000e-07 0 8.176100e-07 0.7 8.178000e-07 0.7
+ 8.178100e-07 0 8.216000e-07 0 8.216100e-07 0.7 8.218000e-07 0.7 8.218100e-07 0 8.256000e-07 0
+ 8.256100e-07 0.7 8.258000e-07 0.7 8.258100e-07 0 8.296000e-07 0 8.296100e-07 0.7 8.298000e-07 0.7
+ 8.298100e-07 0 8.336000e-07 0 8.336100e-07 0.7 8.338000e-07 0.7 8.338100e-07 0 8.376000e-07 0
+ 8.376100e-07 0.7 8.378000e-07 0.7 8.378100e-07 0 8.416000e-07 0 8.416100e-07 0.7 8.418000e-07 0.7
+ 8.418100e-07 0 8.456000e-07 0 8.456100e-07 0.7 8.458000e-07 0.7 8.458100e-07 0 8.496000e-07 0
+ 8.496100e-07 0.7 8.498000e-07 0.7 8.498100e-07 0 8.536000e-07 0 8.536100e-07 0.7 8.538000e-07 0.7
+ 8.538100e-07 0 8.576000e-07 0 8.576100e-07 0.7 8.578000e-07 0.7 8.578100e-07 0 8.616000e-07 0
+ 8.616100e-07 0.7 8.618000e-07 0.7 8.618100e-07 0 8.642000e-07 0 8.642100e-07 0.7 8.652000e-07 0.7
+ 8.652100e-07 0 8.654000e-07 0 8.654100e-07 0.7 8.656000e-07 0.7 8.656100e-07 0 8.658000e-07 0
+ 8.658100e-07 0.7 8.692000e-07 0.7 8.692100e-07 0 8.694000e-07 0 8.694100e-07 0.7 8.696000e-07 0.7
+ 8.696100e-07 0 8.698000e-07 0 8.698100e-07 0.7 8.732000e-07 0.7 8.732100e-07 0 8.734000e-07 0
+ 8.734100e-07 0.7 8.736000e-07 0.7 8.736100e-07 0 8.738000e-07 0 8.738100e-07 0.7 8.772000e-07 0.7
+ 8.772100e-07 0 8.774000e-07 0 8.774100e-07 0.7 8.776000e-07 0.7 8.776100e-07 0 8.778000e-07 0
+ 8.778100e-07 0.7 8.812000e-07 0.7 8.812100e-07 0 8.814000e-07 0 8.814100e-07 0.7 8.816000e-07 0.7
+ 8.816100e-07 0 8.818000e-07 0 8.818100e-07 0.7 8.852000e-07 0.7 8.852100e-07 0 8.854000e-07 0
+ 8.854100e-07 0.7 8.856000e-07 0.7 8.856100e-07 0 8.858000e-07 0 8.858100e-07 0.7 8.892000e-07 0.7
+ 8.892100e-07 0 8.894000e-07 0 8.894100e-07 0.7 8.896000e-07 0.7 8.896100e-07 0 8.898000e-07 0
+ 8.898100e-07 0.7 8.932000e-07 0.7 8.932100e-07 0 8.934000e-07 0 8.934100e-07 0.7 8.936000e-07 0.7
+ 8.936100e-07 0 8.938000e-07 0 8.938100e-07 0.7 8.972000e-07 0.7 8.972100e-07 0 8.974000e-07 0
+ 8.974100e-07 0.7 8.976000e-07 0.7 8.976100e-07 0 8.978000e-07 0 8.978100e-07 0.7 9.012000e-07 0.7
+ 9.012100e-07 0 9.014000e-07 0 9.014100e-07 0.7 9.016000e-07 0.7 9.016100e-07 0 9.018000e-07 0
+ 9.018100e-07 0.7 9.052000e-07 0.7 9.052100e-07 0 9.054000e-07 0 9.054100e-07 0.7 9.056000e-07 0.7
+ 9.056100e-07 0 9.058000e-07 0 9.058100e-07 0.7 9.092000e-07 0.7 9.092100e-07 0 9.094000e-07 0
+ 9.094100e-07 0.7 9.096000e-07 0.7 9.096100e-07 0 9.098000e-07 0 9.098100e-07 0.7 9.132000e-07 0.7
+ 9.132100e-07 0 9.134000e-07 0 9.134100e-07 0.7 9.136000e-07 0.7 9.136100e-07 0 9.138000e-07 0
+ 9.138100e-07 0.7 9.172000e-07 0.7 9.172100e-07 0 9.174000e-07 0 9.174100e-07 0.7 9.176000e-07 0.7
+ 9.176100e-07 0 9.178000e-07 0 9.178100e-07 0.7 9.212000e-07 0.7 9.212100e-07 0 9.214000e-07 0
+ 9.214100e-07 0.7 9.216000e-07 0.7 9.216100e-07 0 9.218000e-07 0 9.218100e-07 0.7 9.252000e-07 0.7
+ 9.252100e-07 0 9.254000e-07 0 9.254100e-07 0.7 9.256000e-07 0.7 9.256100e-07 0 9.258000e-07 0
+ 9.258100e-07 0.7 9.292000e-07 0.7 9.292100e-07 0 9.294000e-07 0 9.294100e-07 0.7 9.296000e-07 0.7
+ 9.296100e-07 0 9.298000e-07 0 9.298100e-07 0.7 9.332000e-07 0.7 9.332100e-07 0 9.334000e-07 0
+ 9.334100e-07 0.7 9.336000e-07 0.7 9.336100e-07 0 9.338000e-07 0 9.338100e-07 0.7 9.372000e-07 0.7
+ 9.372100e-07 0 9.374000e-07 0 9.374100e-07 0.7 9.376000e-07 0.7 9.376100e-07 0 9.378000e-07 0
+ 9.378100e-07 0.7 9.412000e-07 0.7 9.412100e-07 0 9.414000e-07 0 9.414100e-07 0.7 9.416000e-07 0.7
+ 9.416100e-07 0 9.418000e-07 0 9.418100e-07 0.7 9.452000e-07 0.7 9.452100e-07 0 9.454000e-07 0
+ 9.454100e-07 0.7 9.456000e-07 0.7 9.456100e-07 0 9.458000e-07 0 9.458100e-07 0.7 9.492000e-07 0.7
+ 9.492100e-07 0 9.494000e-07 0 9.494100e-07 0.7 9.496000e-07 0.7 9.496100e-07 0 9.498000e-07 0
+ 9.498100e-07 0.7 9.532000e-07 0.7 9.532100e-07 0 9.534000e-07 0 9.534100e-07 0.7 9.536000e-07 0.7
+ 9.536100e-07 0 9.538000e-07 0 9.538100e-07 0.7 9.572000e-07 0.7 9.572100e-07 0 9.574000e-07 0
+ 9.574100e-07 0.7 9.576000e-07 0.7 9.576100e-07 0 9.578000e-07 0 9.578100e-07 0.7 9.612000e-07 0.7
+ 9.612100e-07 0 9.614000e-07 0 9.614100e-07 0.7 9.616000e-07 0.7 9.616100e-07 0 9.618000e-07 0
+ 9.618100e-07 0.7 9.652000e-07 0.7 9.652100e-07 0 9.654000e-07 0 9.654100e-07 0.7 9.656000e-07 0.7
+ 9.656100e-07 0 9.658000e-07 0 9.658100e-07 0.7 9.692000e-07 0.7 9.692100e-07 0 9.694000e-07 0
+ 9.694100e-07 0.7 9.696000e-07 0.7 9.696100e-07 0 9.698000e-07 0 9.698100e-07 0.7 )
v_WB0 src_WB0 0 pwl(
+ 0.000000e+00 0 2.000000e-09 0 2.010000e-09 0.7 2.200000e-09 0.7 2.210000e-09 0 2.400000e-09 0
+ 2.410000e-09 0.7 2.600000e-09 0.7 2.610000e-09 0 6.000000e-09 0 6.010000e-09 0.7 6.200000e-09 0.7
+ 6.210000e-09 0 6.400000e-09 0 6.410000e-09 0.7 6.600000e-09 0.7 6.610000e-09 0 1.000000e-08 0
+ 1.001000e-08 0.7 1.020000e-08 0.7 1.021000e-08 0 1.040000e-08 0 1.041000e-08 0.7 1.060000e-08 0.7
+ 1.061000e-08 0 1.400000e-08 0 1.401000e-08 0.7 1.420000e-08 0.7 1.421000e-08 0 1.440000e-08 0
+ 1.441000e-08 0.7 1.460000e-08 0.7 1.461000e-08 0 1.800000e-08 0 1.801000e-08 0.7 1.820000e-08 0.7
+ 1.821000e-08 0 1.840000e-08 0 1.841000e-08 0.7 1.860000e-08 0.7 1.861000e-08 0 2.200000e-08 0
+ 2.201000e-08 0.7 2.220000e-08 0.7 2.221000e-08 0 2.240000e-08 0 2.241000e-08 0.7 2.260000e-08 0.7
+ 2.261000e-08 0 2.600000e-08 0 2.601000e-08 0.7 2.620000e-08 0.7 2.621000e-08 0 2.640000e-08 0
+ 2.641000e-08 0.7 2.660000e-08 0.7 2.661000e-08 0 3.000000e-08 0 3.001000e-08 0.7 3.020000e-08 0.7
+ 3.021000e-08 0 3.040000e-08 0 3.041000e-08 0.7 3.060000e-08 0.7 3.061000e-08 0 3.400000e-08 0
+ 3.401000e-08 0.7 3.420000e-08 0.7 3.421000e-08 0 3.440000e-08 0 3.441000e-08 0.7 3.460000e-08 0.7
+ 3.461000e-08 0 3.620000e-08 0 3.621000e-08 0.7 3.800000e-08 0.7 3.801000e-08 0 3.820000e-08 0
+ 3.821000e-08 0.7 4.200000e-08 0.7 4.201000e-08 0 4.220000e-08 0 4.221000e-08 0.7 4.600000e-08 0.7
+ 4.601000e-08 0 4.620000e-08 0 4.621000e-08 0.7 5.000000e-08 0.7 5.001000e-08 0 5.020000e-08 0
+ 5.021000e-08 0.7 5.400000e-08 0.7 5.401000e-08 0 5.420000e-08 0 5.421000e-08 0.7 5.800000e-08 0.7
+ 5.801000e-08 0 5.820000e-08 0 5.821000e-08 0.7 6.200000e-08 0.7 6.201000e-08 0 6.220000e-08 0
+ 6.221000e-08 0.7 6.600000e-08 0.7 6.601000e-08 0 6.620000e-08 0 6.621000e-08 0.7 7.000000e-08 0.7
+ 7.001000e-08 0 7.020000e-08 0 7.021000e-08 0.7 7.400000e-08 0.7 7.401000e-08 0 7.420000e-08 0
+ 7.421000e-08 0.7 7.800000e-08 0.7 7.801000e-08 0 7.820000e-08 0 7.821000e-08 0.7 8.200000e-08 0.7
+ 8.201000e-08 0 8.220000e-08 0 8.221000e-08 0.7 8.600000e-08 0.7 8.601000e-08 0 8.620000e-08 0
+ 8.621000e-08 0.7 9.000000e-08 0.7 9.001000e-08 0 9.020000e-08 0 9.021000e-08 0.7 9.400000e-08 0.7
+ 9.401000e-08 0 9.420000e-08 0 9.421000e-08 0.7 9.800000e-08 0.7 9.801000e-08 0 9.820000e-08 0
+ 9.821000e-08 0.7 1.020000e-07 0.7 1.020100e-07 0 1.022000e-07 0 1.022100e-07 0.7 1.060000e-07 0.7
+ 1.060100e-07 0 1.062000e-07 0 1.062100e-07 0.7 1.082000e-07 0.7 1.082100e-07 0 1.100000e-07 0
+ 1.100100e-07 0.7 1.102000e-07 0.7 1.102100e-07 0 1.104000e-07 0 1.104100e-07 0.7 1.106000e-07 0.7
+ 1.106100e-07 0 1.140000e-07 0 1.140100e-07 0.7 1.142000e-07 0.7 1.142100e-07 0 1.144000e-07 0
+ 1.144100e-07 0.7 1.146000e-07 0.7 1.146100e-07 0 1.180000e-07 0 1.180100e-07 0.7 1.182000e-07 0.7
+ 1.182100e-07 0 1.184000e-07 0 1.184100e-07 0.7 1.186000e-07 0.7 1.186100e-07 0 1.220000e-07 0
+ 1.220100e-07 0.7 1.222000e-07 0.7 1.222100e-07 0 1.224000e-07 0 1.224100e-07 0.7 1.226000e-07 0.7
+ 1.226100e-07 0 1.260000e-07 0 1.260100e-07 0.7 1.262000e-07 0.7 1.262100e-07 0 1.264000e-07 0
+ 1.264100e-07 0.7 1.266000e-07 0.7 1.266100e-07 0 1.300000e-07 0 1.300100e-07 0.7 1.302000e-07 0.7
+ 1.302100e-07 0 1.304000e-07 0 1.304100e-07 0.7 1.306000e-07 0.7 1.306100e-07 0 1.340000e-07 0
+ 1.340100e-07 0.7 1.342000e-07 0.7 1.342100e-07 0 1.344000e-07 0 1.344100e-07 0.7 1.346000e-07 0.7
+ 1.346100e-07 0 1.380000e-07 0 1.380100e-07 0.7 1.382000e-07 0.7 1.382100e-07 0 1.384000e-07 0
+ 1.384100e-07 0.7 1.386000e-07 0.7 1.386100e-07 0 1.420000e-07 0 1.420100e-07 0.7 1.422000e-07 0.7
+ 1.422100e-07 0 1.424000e-07 0 1.424100e-07 0.7 1.426000e-07 0.7 1.426100e-07 0 1.442000e-07 0
+ 1.442100e-07 0.7 1.460000e-07 0.7 1.460100e-07 0 1.462000e-07 0 1.462100e-07 0.7 1.500000e-07 0.7
+ 1.500100e-07 0 1.502000e-07 0 1.502100e-07 0.7 1.540000e-07 0.7 1.540100e-07 0 1.542000e-07 0
+ 1.542100e-07 0.7 1.580000e-07 0.7 1.580100e-07 0 1.582000e-07 0 1.582100e-07 0.7 1.620000e-07 0.7
+ 1.620100e-07 0 1.622000e-07 0 1.622100e-07 0.7 1.660000e-07 0.7 1.660100e-07 0 1.662000e-07 0
+ 1.662100e-07 0.7 1.700000e-07 0.7 1.700100e-07 0 1.702000e-07 0 1.702100e-07 0.7 1.740000e-07 0.7
+ 1.740100e-07 0 1.742000e-07 0 1.742100e-07 0.7 1.780000e-07 0.7 1.780100e-07 0 1.782000e-07 0
+ 1.782100e-07 0.7 1.820000e-07 0.7 1.820100e-07 0 1.822000e-07 0 1.822100e-07 0.7 1.860000e-07 0.7
+ 1.860100e-07 0 1.862000e-07 0 1.862100e-07 0.7 1.900000e-07 0.7 1.900100e-07 0 1.902000e-07 0
+ 1.902100e-07 0.7 1.940000e-07 0.7 1.940100e-07 0 1.942000e-07 0 1.942100e-07 0.7 1.980000e-07 0.7
+ 1.980100e-07 0 1.982000e-07 0 1.982100e-07 0.7 2.020000e-07 0.7 2.020100e-07 0 2.022000e-07 0
+ 2.022100e-07 0.7 2.060000e-07 0.7 2.060100e-07 0 2.062000e-07 0 2.062100e-07 0.7 2.100000e-07 0.7
+ 2.100100e-07 0 2.102000e-07 0 2.102100e-07 0.7 2.140000e-07 0.7 2.140100e-07 0 2.142000e-07 0
+ 2.142100e-07 0.7 2.162000e-07 0.7 2.162100e-07 0 2.180000e-07 0 2.180100e-07 0.7 2.182000e-07 0.7
+ 2.182100e-07 0 2.184000e-07 0 2.184100e-07 0.7 2.186000e-07 0.7 2.186100e-07 0 2.220000e-07 0
+ 2.220100e-07 0.7 2.222000e-07 0.7 2.222100e-07 0 2.224000e-07 0 2.224100e-07 0.7 2.226000e-07 0.7
+ 2.226100e-07 0 2.260000e-07 0 2.260100e-07 0.7 2.262000e-07 0.7 2.262100e-07 0 2.264000e-07 0
+ 2.264100e-07 0.7 2.266000e-07 0.7 2.266100e-07 0 2.300000e-07 0 2.300100e-07 0.7 2.302000e-07 0.7
+ 2.302100e-07 0 2.304000e-07 0 2.304100e-07 0.7 2.306000e-07 0.7 2.306100e-07 0 2.340000e-07 0
+ 2.340100e-07 0.7 2.342000e-07 0.7 2.342100e-07 0 2.344000e-07 0 2.344100e-07 0.7 2.346000e-07 0.7
+ 2.346100e-07 0 2.380000e-07 0 2.380100e-07 0.7 2.382000e-07 0.7 2.382100e-07 0 2.384000e-07 0
+ 2.384100e-07 0.7 2.386000e-07 0.7 2.386100e-07 0 2.420000e-07 0 2.420100e-07 0.7 2.422000e-07 0.7
+ 2.422100e-07 0 2.424000e-07 0 2.424100e-07 0.7 2.426000e-07 0.7 2.426100e-07 0 2.460000e-07 0
+ 2.460100e-07 0.7 2.462000e-07 0.7 2.462100e-07 0 2.464000e-07 0 2.464100e-07 0.7 2.466000e-07 0.7
+ 2.466100e-07 0 2.500000e-07 0 2.500100e-07 0.7 2.502000e-07 0.7 2.502100e-07 0 2.504000e-07 0
+ 2.504100e-07 0.7 2.506000e-07 0.7 2.506100e-07 0 2.522000e-07 0 2.522100e-07 0.7 2.540000e-07 0.7
+ 2.540100e-07 0 2.542000e-07 0 2.542100e-07 0.7 2.580000e-07 0.7 2.580100e-07 0 2.582000e-07 0
+ 2.582100e-07 0.7 2.620000e-07 0.7 2.620100e-07 0 2.622000e-07 0 2.622100e-07 0.7 2.660000e-07 0.7
+ 2.660100e-07 0 2.662000e-07 0 2.662100e-07 0.7 2.700000e-07 0.7 2.700100e-07 0 2.702000e-07 0
+ 2.702100e-07 0.7 2.740000e-07 0.7 2.740100e-07 0 2.742000e-07 0 2.742100e-07 0.7 2.780000e-07 0.7
+ 2.780100e-07 0 2.782000e-07 0 2.782100e-07 0.7 2.820000e-07 0.7 2.820100e-07 0 2.822000e-07 0
+ 2.822100e-07 0.7 2.860000e-07 0.7 2.860100e-07 0 2.862000e-07 0 2.862100e-07 0.7 2.900000e-07 0.7
+ 2.900100e-07 0 2.902000e-07 0 2.902100e-07 0.7 2.940000e-07 0.7 2.940100e-07 0 2.942000e-07 0
+ 2.942100e-07 0.7 2.980000e-07 0.7 2.980100e-07 0 2.982000e-07 0 2.982100e-07 0.7 3.020000e-07 0.7
+ 3.020100e-07 0 3.022000e-07 0 3.022100e-07 0.7 3.060000e-07 0.7 3.060100e-07 0 3.062000e-07 0
+ 3.062100e-07 0.7 3.100000e-07 0.7 3.100100e-07 0 3.102000e-07 0 3.102100e-07 0.7 3.140000e-07 0.7
+ 3.140100e-07 0 3.142000e-07 0 3.142100e-07 0.7 3.180000e-07 0.7 3.180100e-07 0 3.182000e-07 0
+ 3.182100e-07 0.7 3.220000e-07 0.7 3.220100e-07 0 3.222000e-07 0 3.222100e-07 0.7 3.242000e-07 0.7
+ 3.242100e-07 0 3.260000e-07 0 3.260100e-07 0.7 3.262000e-07 0.7 3.262100e-07 0 3.264000e-07 0
+ 3.264100e-07 0.7 3.266000e-07 0.7 3.266100e-07 0 3.300000e-07 0 3.300100e-07 0.7 3.302000e-07 0.7
+ 3.302100e-07 0 3.304000e-07 0 3.304100e-07 0.7 3.306000e-07 0.7 3.306100e-07 0 3.340000e-07 0
+ 3.340100e-07 0.7 3.342000e-07 0.7 3.342100e-07 0 3.344000e-07 0 3.344100e-07 0.7 3.346000e-07 0.7
+ 3.346100e-07 0 3.380000e-07 0 3.380100e-07 0.7 3.382000e-07 0.7 3.382100e-07 0 3.384000e-07 0
+ 3.384100e-07 0.7 3.386000e-07 0.7 3.386100e-07 0 3.420000e-07 0 3.420100e-07 0.7 3.422000e-07 0.7
+ 3.422100e-07 0 3.424000e-07 0 3.424100e-07 0.7 3.426000e-07 0.7 3.426100e-07 0 3.460000e-07 0
+ 3.460100e-07 0.7 3.462000e-07 0.7 3.462100e-07 0 3.464000e-07 0 3.464100e-07 0.7 3.466000e-07 0.7
+ 3.466100e-07 0 3.500000e-07 0 3.500100e-07 0.7 3.502000e-07 0.7 3.502100e-07 0 3.504000e-07 0
+ 3.504100e-07 0.7 3.506000e-07 0.7 3.506100e-07 0 3.540000e-07 0 3.540100e-07 0.7 3.542000e-07 0.7
+ 3.542100e-07 0 3.544000e-07 0 3.544100e-07 0.7 3.546000e-07 0.7 3.546100e-07 0 3.580000e-07 0
+ 3.580100e-07 0.7 3.582000e-07 0.7 3.582100e-07 0 3.584000e-07 0 3.584100e-07 0.7 3.586000e-07 0.7
+ 3.586100e-07 0 3.602000e-07 0 3.602100e-07 0.7 3.620000e-07 0.7 3.620100e-07 0 3.622000e-07 0
+ 3.622100e-07 0.7 3.660000e-07 0.7 3.660100e-07 0 3.662000e-07 0 3.662100e-07 0.7 3.700000e-07 0.7
+ 3.700100e-07 0 3.702000e-07 0 3.702100e-07 0.7 3.740000e-07 0.7 3.740100e-07 0 3.742000e-07 0
+ 3.742100e-07 0.7 3.780000e-07 0.7 3.780100e-07 0 3.782000e-07 0 3.782100e-07 0.7 3.820000e-07 0.7
+ 3.820100e-07 0 3.822000e-07 0 3.822100e-07 0.7 3.860000e-07 0.7 3.860100e-07 0 3.862000e-07 0
+ 3.862100e-07 0.7 3.900000e-07 0.7 3.900100e-07 0 3.902000e-07 0 3.902100e-07 0.7 3.940000e-07 0.7
+ 3.940100e-07 0 3.942000e-07 0 3.942100e-07 0.7 3.980000e-07 0.7 3.980100e-07 0 3.982000e-07 0
+ 3.982100e-07 0.7 4.020000e-07 0.7 4.020100e-07 0 4.022000e-07 0 4.022100e-07 0.7 4.060000e-07 0.7
+ 4.060100e-07 0 4.062000e-07 0 4.062100e-07 0.7 4.100000e-07 0.7 4.100100e-07 0 4.102000e-07 0
+ 4.102100e-07 0.7 4.140000e-07 0.7 4.140100e-07 0 4.142000e-07 0 4.142100e-07 0.7 4.180000e-07 0.7
+ 4.180100e-07 0 4.182000e-07 0 4.182100e-07 0.7 4.220000e-07 0.7 4.220100e-07 0 4.222000e-07 0
+ 4.222100e-07 0.7 4.260000e-07 0.7 4.260100e-07 0 4.262000e-07 0 4.262100e-07 0.7 4.300000e-07 0.7
+ 4.300100e-07 0 4.302000e-07 0 4.302100e-07 0.7 4.322000e-07 0.7 4.322100e-07 0 4.340000e-07 0
+ 4.340100e-07 0.7 4.342000e-07 0.7 4.342100e-07 0 4.344000e-07 0 4.344100e-07 0.7 4.346000e-07 0.7
+ 4.346100e-07 0 4.380000e-07 0 4.380100e-07 0.7 4.382000e-07 0.7 4.382100e-07 0 4.384000e-07 0
+ 4.384100e-07 0.7 4.386000e-07 0.7 4.386100e-07 0 4.420000e-07 0 4.420100e-07 0.7 4.422000e-07 0.7
+ 4.422100e-07 0 4.424000e-07 0 4.424100e-07 0.7 4.426000e-07 0.7 4.426100e-07 0 4.460000e-07 0
+ 4.460100e-07 0.7 4.462000e-07 0.7 4.462100e-07 0 4.464000e-07 0 4.464100e-07 0.7 4.466000e-07 0.7
+ 4.466100e-07 0 4.500000e-07 0 4.500100e-07 0.7 4.502000e-07 0.7 4.502100e-07 0 4.504000e-07 0
+ 4.504100e-07 0.7 4.506000e-07 0.7 4.506100e-07 0 4.540000e-07 0 4.540100e-07 0.7 4.542000e-07 0.7
+ 4.542100e-07 0 4.544000e-07 0 4.544100e-07 0.7 4.546000e-07 0.7 4.546100e-07 0 4.580000e-07 0
+ 4.580100e-07 0.7 4.582000e-07 0.7 4.582100e-07 0 4.584000e-07 0 4.584100e-07 0.7 4.586000e-07 0.7
+ 4.586100e-07 0 4.620000e-07 0 4.620100e-07 0.7 4.622000e-07 0.7 4.622100e-07 0 4.624000e-07 0
+ 4.624100e-07 0.7 4.626000e-07 0.7 4.626100e-07 0 4.660000e-07 0 4.660100e-07 0.7 4.662000e-07 0.7
+ 4.662100e-07 0 4.664000e-07 0 4.664100e-07 0.7 4.666000e-07 0.7 4.666100e-07 0 4.682000e-07 0
+ 4.682100e-07 0.7 4.700000e-07 0.7 4.700100e-07 0 4.702000e-07 0 4.702100e-07 0.7 4.740000e-07 0.7
+ 4.740100e-07 0 4.742000e-07 0 4.742100e-07 0.7 4.780000e-07 0.7 4.780100e-07 0 4.782000e-07 0
+ 4.782100e-07 0.7 4.820000e-07 0.7 4.820100e-07 0 4.822000e-07 0 4.822100e-07 0.7 4.860000e-07 0.7
+ 4.860100e-07 0 4.862000e-07 0 4.862100e-07 0.7 4.900000e-07 0.7 4.900100e-07 0 4.902000e-07 0
+ 4.902100e-07 0.7 4.940000e-07 0.7 4.940100e-07 0 4.942000e-07 0 4.942100e-07 0.7 4.980000e-07 0.7
+ 4.980100e-07 0 4.982000e-07 0 4.982100e-07 0.7 5.020000e-07 0.7 5.020100e-07 0 5.022000e-07 0
+ 5.022100e-07 0.7 5.060000e-07 0.7 5.060100e-07 0 5.062000e-07 0 5.062100e-07 0.7 5.100000e-07 0.7
+ 5.100100e-07 0 5.102000e-07 0 5.102100e-07 0.7 5.140000e-07 0.7 5.140100e-07 0 5.142000e-07 0
+ 5.142100e-07 0.7 5.180000e-07 0.7 5.180100e-07 0 5.182000e-07 0 5.182100e-07 0.7 5.220000e-07 0.7
+ 5.220100e-07 0 5.222000e-07 0 5.222100e-07 0.7 5.260000e-07 0.7 5.260100e-07 0 5.262000e-07 0
+ 5.262100e-07 0.7 5.300000e-07 0.7 5.300100e-07 0 5.302000e-07 0 5.302100e-07 0.7 5.340000e-07 0.7
+ 5.340100e-07 0 5.342000e-07 0 5.342100e-07 0.7 5.380000e-07 0.7 5.380100e-07 0 5.382000e-07 0
+ 5.382100e-07 0.7 5.402000e-07 0.7 5.402100e-07 0 5.420000e-07 0 5.420100e-07 0.7 5.422000e-07 0.7
+ 5.422100e-07 0 5.424000e-07 0 5.424100e-07 0.7 5.426000e-07 0.7 5.426100e-07 0 5.460000e-07 0
+ 5.460100e-07 0.7 5.462000e-07 0.7 5.462100e-07 0 5.464000e-07 0 5.464100e-07 0.7 5.466000e-07 0.7
+ 5.466100e-07 0 5.500000e-07 0 5.500100e-07 0.7 5.502000e-07 0.7 5.502100e-07 0 5.504000e-07 0
+ 5.504100e-07 0.7 5.506000e-07 0.7 5.506100e-07 0 5.540000e-07 0 5.540100e-07 0.7 5.542000e-07 0.7
+ 5.542100e-07 0 5.544000e-07 0 5.544100e-07 0.7 5.546000e-07 0.7 5.546100e-07 0 5.580000e-07 0
+ 5.580100e-07 0.7 5.582000e-07 0.7 5.582100e-07 0 5.584000e-07 0 5.584100e-07 0.7 5.586000e-07 0.7
+ 5.586100e-07 0 5.620000e-07 0 5.620100e-07 0.7 5.622000e-07 0.7 5.622100e-07 0 5.624000e-07 0
+ 5.624100e-07 0.7 5.626000e-07 0.7 5.626100e-07 0 5.660000e-07 0 5.660100e-07 0.7 5.662000e-07 0.7
+ 5.662100e-07 0 5.664000e-07 0 5.664100e-07 0.7 5.666000e-07 0.7 5.666100e-07 0 5.700000e-07 0
+ 5.700100e-07 0.7 5.702000e-07 0.7 5.702100e-07 0 5.704000e-07 0 5.704100e-07 0.7 5.706000e-07 0.7
+ 5.706100e-07 0 5.740000e-07 0 5.740100e-07 0.7 5.742000e-07 0.7 5.742100e-07 0 5.744000e-07 0
+ 5.744100e-07 0.7 5.746000e-07 0.7 5.746100e-07 0 5.762000e-07 0 5.762100e-07 0.7 5.780000e-07 0.7
+ 5.780100e-07 0 5.782000e-07 0 5.782100e-07 0.7 5.820000e-07 0.7 5.820100e-07 0 5.822000e-07 0
+ 5.822100e-07 0.7 5.860000e-07 0.7 5.860100e-07 0 5.862000e-07 0 5.862100e-07 0.7 5.900000e-07 0.7
+ 5.900100e-07 0 5.902000e-07 0 5.902100e-07 0.7 5.940000e-07 0.7 5.940100e-07 0 5.942000e-07 0
+ 5.942100e-07 0.7 5.980000e-07 0.7 5.980100e-07 0 5.982000e-07 0 5.982100e-07 0.7 6.020000e-07 0.7
+ 6.020100e-07 0 6.022000e-07 0 6.022100e-07 0.7 6.060000e-07 0.7 6.060100e-07 0 6.062000e-07 0
+ 6.062100e-07 0.7 6.100000e-07 0.7 6.100100e-07 0 6.102000e-07 0 6.102100e-07 0.7 6.140000e-07 0.7
+ 6.140100e-07 0 6.142000e-07 0 6.142100e-07 0.7 6.180000e-07 0.7 6.180100e-07 0 6.182000e-07 0
+ 6.182100e-07 0.7 6.220000e-07 0.7 6.220100e-07 0 6.222000e-07 0 6.222100e-07 0.7 6.260000e-07 0.7
+ 6.260100e-07 0 6.262000e-07 0 6.262100e-07 0.7 6.300000e-07 0.7 6.300100e-07 0 6.302000e-07 0
+ 6.302100e-07 0.7 6.340000e-07 0.7 6.340100e-07 0 6.342000e-07 0 6.342100e-07 0.7 6.380000e-07 0.7
+ 6.380100e-07 0 6.382000e-07 0 6.382100e-07 0.7 6.420000e-07 0.7 6.420100e-07 0 6.422000e-07 0
+ 6.422100e-07 0.7 6.460000e-07 0.7 6.460100e-07 0 6.462000e-07 0 6.462100e-07 0.7 6.482000e-07 0.7
+ 6.482100e-07 0 6.500000e-07 0 6.500100e-07 0.7 6.502000e-07 0.7 6.502100e-07 0 6.504000e-07 0
+ 6.504100e-07 0.7 6.506000e-07 0.7 6.506100e-07 0 6.540000e-07 0 6.540100e-07 0.7 6.542000e-07 0.7
+ 6.542100e-07 0 6.544000e-07 0 6.544100e-07 0.7 6.546000e-07 0.7 6.546100e-07 0 6.580000e-07 0
+ 6.580100e-07 0.7 6.582000e-07 0.7 6.582100e-07 0 6.584000e-07 0 6.584100e-07 0.7 6.586000e-07 0.7
+ 6.586100e-07 0 6.620000e-07 0 6.620100e-07 0.7 6.622000e-07 0.7 6.622100e-07 0 6.624000e-07 0
+ 6.624100e-07 0.7 6.626000e-07 0.7 6.626100e-07 0 6.660000e-07 0 6.660100e-07 0.7 6.662000e-07 0.7
+ 6.662100e-07 0 6.664000e-07 0 6.664100e-07 0.7 6.666000e-07 0.7 6.666100e-07 0 6.700000e-07 0
+ 6.700100e-07 0.7 6.702000e-07 0.7 6.702100e-07 0 6.704000e-07 0 6.704100e-07 0.7 6.706000e-07 0.7
+ 6.706100e-07 0 6.740000e-07 0 6.740100e-07 0.7 6.742000e-07 0.7 6.742100e-07 0 6.744000e-07 0
+ 6.744100e-07 0.7 6.746000e-07 0.7 6.746100e-07 0 6.780000e-07 0 6.780100e-07 0.7 6.782000e-07 0.7
+ 6.782100e-07 0 6.784000e-07 0 6.784100e-07 0.7 6.786000e-07 0.7 6.786100e-07 0 6.820000e-07 0
+ 6.820100e-07 0.7 6.822000e-07 0.7 6.822100e-07 0 6.824000e-07 0 6.824100e-07 0.7 6.826000e-07 0.7
+ 6.826100e-07 0 6.842000e-07 0 6.842100e-07 0.7 6.860000e-07 0.7 6.860100e-07 0 6.862000e-07 0
+ 6.862100e-07 0.7 6.900000e-07 0.7 6.900100e-07 0 6.902000e-07 0 6.902100e-07 0.7 6.940000e-07 0.7
+ 6.940100e-07 0 6.942000e-07 0 6.942100e-07 0.7 6.980000e-07 0.7 6.980100e-07 0 6.982000e-07 0
+ 6.982100e-07 0.7 7.020000e-07 0.7 7.020100e-07 0 7.022000e-07 0 7.022100e-07 0.7 7.060000e-07 0.7
+ 7.060100e-07 0 7.062000e-07 0 7.062100e-07 0.7 7.100000e-07 0.7 7.100100e-07 0 7.102000e-07 0
+ 7.102100e-07 0.7 7.140000e-07 0.7 7.140100e-07 0 7.142000e-07 0 7.142100e-07 0.7 7.180000e-07 0.7
+ 7.180100e-07 0 7.182000e-07 0 7.182100e-07 0.7 7.220000e-07 0.7 7.220100e-07 0 7.222000e-07 0
+ 7.222100e-07 0.7 7.260000e-07 0.7 7.260100e-07 0 7.262000e-07 0 7.262100e-07 0.7 7.300000e-07 0.7
+ 7.300100e-07 0 7.302000e-07 0 7.302100e-07 0.7 7.340000e-07 0.7 7.340100e-07 0 7.342000e-07 0
+ 7.342100e-07 0.7 7.380000e-07 0.7 7.380100e-07 0 7.382000e-07 0 7.382100e-07 0.7 7.420000e-07 0.7
+ 7.420100e-07 0 7.422000e-07 0 7.422100e-07 0.7 7.460000e-07 0.7 7.460100e-07 0 7.462000e-07 0
+ 7.462100e-07 0.7 7.500000e-07 0.7 7.500100e-07 0 7.502000e-07 0 7.502100e-07 0.7 7.540000e-07 0.7
+ 7.540100e-07 0 7.542000e-07 0 7.542100e-07 0.7 7.562000e-07 0.7 7.562100e-07 0 7.580000e-07 0
+ 7.580100e-07 0.7 7.582000e-07 0.7 7.582100e-07 0 7.584000e-07 0 7.584100e-07 0.7 7.586000e-07 0.7
+ 7.586100e-07 0 7.620000e-07 0 7.620100e-07 0.7 7.622000e-07 0.7 7.622100e-07 0 7.624000e-07 0
+ 7.624100e-07 0.7 7.626000e-07 0.7 7.626100e-07 0 7.660000e-07 0 7.660100e-07 0.7 7.662000e-07 0.7
+ 7.662100e-07 0 7.664000e-07 0 7.664100e-07 0.7 7.666000e-07 0.7 7.666100e-07 0 7.700000e-07 0
+ 7.700100e-07 0.7 7.702000e-07 0.7 7.702100e-07 0 7.704000e-07 0 7.704100e-07 0.7 7.706000e-07 0.7
+ 7.706100e-07 0 7.740000e-07 0 7.740100e-07 0.7 7.742000e-07 0.7 7.742100e-07 0 7.744000e-07 0
+ 7.744100e-07 0.7 7.746000e-07 0.7 7.746100e-07 0 7.780000e-07 0 7.780100e-07 0.7 7.782000e-07 0.7
+ 7.782100e-07 0 7.784000e-07 0 7.784100e-07 0.7 7.786000e-07 0.7 7.786100e-07 0 7.820000e-07 0
+ 7.820100e-07 0.7 7.822000e-07 0.7 7.822100e-07 0 7.824000e-07 0 7.824100e-07 0.7 7.826000e-07 0.7
+ 7.826100e-07 0 7.860000e-07 0 7.860100e-07 0.7 7.862000e-07 0.7 7.862100e-07 0 7.864000e-07 0
+ 7.864100e-07 0.7 7.866000e-07 0.7 7.866100e-07 0 7.900000e-07 0 7.900100e-07 0.7 7.902000e-07 0.7
+ 7.902100e-07 0 7.904000e-07 0 7.904100e-07 0.7 7.906000e-07 0.7 7.906100e-07 0 7.922000e-07 0
+ 7.922100e-07 0.7 7.940000e-07 0.7 7.940100e-07 0 7.942000e-07 0 7.942100e-07 0.7 7.980000e-07 0.7
+ 7.980100e-07 0 7.982000e-07 0 7.982100e-07 0.7 8.020000e-07 0.7 8.020100e-07 0 8.022000e-07 0
+ 8.022100e-07 0.7 8.060000e-07 0.7 8.060100e-07 0 8.062000e-07 0 8.062100e-07 0.7 8.100000e-07 0.7
+ 8.100100e-07 0 8.102000e-07 0 8.102100e-07 0.7 8.140000e-07 0.7 8.140100e-07 0 8.142000e-07 0
+ 8.142100e-07 0.7 8.180000e-07 0.7 8.180100e-07 0 8.182000e-07 0 8.182100e-07 0.7 8.220000e-07 0.7
+ 8.220100e-07 0 8.222000e-07 0 8.222100e-07 0.7 8.260000e-07 0.7 8.260100e-07 0 8.262000e-07 0
+ 8.262100e-07 0.7 8.300000e-07 0.7 8.300100e-07 0 8.302000e-07 0 8.302100e-07 0.7 8.340000e-07 0.7
+ 8.340100e-07 0 8.342000e-07 0 8.342100e-07 0.7 8.380000e-07 0.7 8.380100e-07 0 8.382000e-07 0
+ 8.382100e-07 0.7 8.420000e-07 0.7 8.420100e-07 0 8.422000e-07 0 8.422100e-07 0.7 8.460000e-07 0.7
+ 8.460100e-07 0 8.462000e-07 0 8.462100e-07 0.7 8.500000e-07 0.7 8.500100e-07 0 8.502000e-07 0
+ 8.502100e-07 0.7 8.540000e-07 0.7 8.540100e-07 0 8.542000e-07 0 8.542100e-07 0.7 8.580000e-07 0.7
+ 8.580100e-07 0 8.582000e-07 0 8.582100e-07 0.7 8.620000e-07 0.7 8.620100e-07 0 8.622000e-07 0
+ 8.622100e-07 0.7 8.642000e-07 0.7 8.642100e-07 0 8.660000e-07 0 8.660100e-07 0.7 8.662000e-07 0.7
+ 8.662100e-07 0 8.664000e-07 0 8.664100e-07 0.7 8.666000e-07 0.7 8.666100e-07 0 8.700000e-07 0
+ 8.700100e-07 0.7 8.702000e-07 0.7 8.702100e-07 0 8.704000e-07 0 8.704100e-07 0.7 8.706000e-07 0.7
+ 8.706100e-07 0 8.740000e-07 0 8.740100e-07 0.7 8.742000e-07 0.7 8.742100e-07 0 8.744000e-07 0
+ 8.744100e-07 0.7 8.746000e-07 0.7 8.746100e-07 0 8.780000e-07 0 8.780100e-07 0.7 8.782000e-07 0.7
+ 8.782100e-07 0 8.784000e-07 0 8.784100e-07 0.7 8.786000e-07 0.7 8.786100e-07 0 8.820000e-07 0
+ 8.820100e-07 0.7 8.822000e-07 0.7 8.822100e-07 0 8.824000e-07 0 8.824100e-07 0.7 8.826000e-07 0.7
+ 8.826100e-07 0 8.860000e-07 0 8.860100e-07 0.7 8.862000e-07 0.7 8.862100e-07 0 8.864000e-07 0
+ 8.864100e-07 0.7 8.866000e-07 0.7 8.866100e-07 0 8.900000e-07 0 8.900100e-07 0.7 8.902000e-07 0.7
+ 8.902100e-07 0 8.904000e-07 0 8.904100e-07 0.7 8.906000e-07 0.7 8.906100e-07 0 8.940000e-07 0
+ 8.940100e-07 0.7 8.942000e-07 0.7 8.942100e-07 0 8.944000e-07 0 8.944100e-07 0.7 8.946000e-07 0.7
+ 8.946100e-07 0 8.980000e-07 0 8.980100e-07 0.7 8.982000e-07 0.7 8.982100e-07 0 8.984000e-07 0
+ 8.984100e-07 0.7 8.986000e-07 0.7 8.986100e-07 0 9.002000e-07 0 9.002100e-07 0.7 9.020000e-07 0.7
+ 9.020100e-07 0 9.022000e-07 0 9.022100e-07 0.7 9.060000e-07 0.7 9.060100e-07 0 9.062000e-07 0
+ 9.062100e-07 0.7 9.100000e-07 0.7 9.100100e-07 0 9.102000e-07 0 9.102100e-07 0.7 9.140000e-07 0.7
+ 9.140100e-07 0 9.142000e-07 0 9.142100e-07 0.7 9.180000e-07 0.7 9.180100e-07 0 9.182000e-07 0
+ 9.182100e-07 0.7 9.220000e-07 0.7 9.220100e-07 0 9.222000e-07 0 9.222100e-07 0.7 9.260000e-07 0.7
+ 9.260100e-07 0 9.262000e-07 0 9.262100e-07 0.7 9.300000e-07 0.7 9.300100e-07 0 9.302000e-07 0
+ 9.302100e-07 0.7 9.340000e-07 0.7 9.340100e-07 0 9.342000e-07 0 9.342100e-07 0.7 9.380000e-07 0.7
+ 9.380100e-07 0 9.382000e-07 0 9.382100e-07 0.7 9.420000e-07 0.7 9.420100e-07 0 9.422000e-07 0
+ 9.422100e-07 0.7 9.460000e-07 0.7 9.460100e-07 0 9.462000e-07 0 9.462100e-07 0.7 9.500000e-07 0.7
+ 9.500100e-07 0 9.502000e-07 0 9.502100e-07 0.7 9.540000e-07 0.7 9.540100e-07 0 9.542000e-07 0
+ 9.542100e-07 0.7 9.580000e-07 0.7 9.580100e-07 0 9.582000e-07 0 9.582100e-07 0.7 9.620000e-07 0.7
+ 9.620100e-07 0 9.622000e-07 0 9.622100e-07 0.7 9.660000e-07 0.7 9.660100e-07 0 9.662000e-07 0
+ 9.662100e-07 0.7 9.700000e-07 0.7 9.700100e-07 0 9.702000e-07 0 9.702100e-07 0.7 )
v_WB1 src_WB1 0 pwl(
+ 0.000000e+00 0 2.400000e-09 0 2.410000e-09 0.7 2.600000e-09 0.7 2.610000e-09 0 6.400000e-09 0
+ 6.410000e-09 0.7 6.600000e-09 0.7 6.610000e-09 0 1.040000e-08 0 1.041000e-08 0.7 1.060000e-08 0.7
+ 1.061000e-08 0 1.440000e-08 0 1.441000e-08 0.7 1.460000e-08 0.7 1.461000e-08 0 1.840000e-08 0
+ 1.841000e-08 0.7 1.860000e-08 0.7 1.861000e-08 0 2.240000e-08 0 2.241000e-08 0.7 2.260000e-08 0.7
+ 2.261000e-08 0 2.640000e-08 0 2.641000e-08 0.7 2.660000e-08 0.7 2.661000e-08 0 3.040000e-08 0
+ 3.041000e-08 0.7 3.060000e-08 0.7 3.061000e-08 0 3.440000e-08 0 3.441000e-08 0.7 3.460000e-08 0.7
+ 3.461000e-08 0 3.840000e-08 0 3.841000e-08 0.7 3.860000e-08 0.7 3.861000e-08 0 4.240000e-08 0
+ 4.241000e-08 0.7 4.260000e-08 0.7 4.261000e-08 0 4.640000e-08 0 4.641000e-08 0.7 4.660000e-08 0.7
+ 4.661000e-08 0 5.040000e-08 0 5.041000e-08 0.7 5.060000e-08 0.7 5.061000e-08 0 5.440000e-08 0
+ 5.441000e-08 0.7 5.460000e-08 0.7 5.461000e-08 0 5.840000e-08 0 5.841000e-08 0.7 5.860000e-08 0.7
+ 5.861000e-08 0 6.240000e-08 0 6.241000e-08 0.7 6.260000e-08 0.7 6.261000e-08 0 6.640000e-08 0
+ 6.641000e-08 0.7 6.660000e-08 0.7 6.661000e-08 0 7.040000e-08 0 7.041000e-08 0.7 7.060000e-08 0.7
+ 7.061000e-08 0 7.220000e-08 0 7.221000e-08 0.7 7.400000e-08 0.7 7.401000e-08 0 7.420000e-08 0
+ 7.421000e-08 0.7 7.440000e-08 0.7 7.441000e-08 0 7.460000e-08 0 7.461000e-08 0.7 7.800000e-08 0.7
+ 7.801000e-08 0 7.820000e-08 0 7.821000e-08 0.7 7.840000e-08 0.7 7.841000e-08 0 7.860000e-08 0
+ 7.861000e-08 0.7 8.200000e-08 0.7 8.201000e-08 0 8.220000e-08 0 8.221000e-08 0.7 8.240000e-08 0.7
+ 8.241000e-08 0 8.260000e-08 0 8.261000e-08 0.7 8.600000e-08 0.7 8.601000e-08 0 8.620000e-08 0
+ 8.621000e-08 0.7 8.640000e-08 0.7 8.641000e-08 0 8.660000e-08 0 8.661000e-08 0.7 9.000000e-08 0.7
+ 9.001000e-08 0 9.020000e-08 0 9.021000e-08 0.7 9.040000e-08 0.7 9.041000e-08 0 9.060000e-08 0
+ 9.061000e-08 0.7 9.400000e-08 0.7 9.401000e-08 0 9.420000e-08 0 9.421000e-08 0.7 9.440000e-08 0.7
+ 9.441000e-08 0 9.460000e-08 0 9.461000e-08 0.7 9.800000e-08 0.7 9.801000e-08 0 9.820000e-08 0
+ 9.821000e-08 0.7 9.840000e-08 0.7 9.841000e-08 0 9.860000e-08 0 9.861000e-08 0.7 1.020000e-07 0.7
+ 1.020100e-07 0 1.022000e-07 0 1.022100e-07 0.7 1.024000e-07 0.7 1.024100e-07 0 1.026000e-07 0
+ 1.026100e-07 0.7 1.060000e-07 0.7 1.060100e-07 0 1.062000e-07 0 1.062100e-07 0.7 1.064000e-07 0.7
+ 1.064100e-07 0 1.066000e-07 0 1.066100e-07 0.7 1.082000e-07 0.7 1.082100e-07 0 1.104000e-07 0
+ 1.104100e-07 0.7 1.106000e-07 0.7 1.106100e-07 0 1.144000e-07 0 1.144100e-07 0.7 1.146000e-07 0.7
+ 1.146100e-07 0 1.184000e-07 0 1.184100e-07 0.7 1.186000e-07 0.7 1.186100e-07 0 1.224000e-07 0
+ 1.224100e-07 0.7 1.226000e-07 0.7 1.226100e-07 0 1.264000e-07 0 1.264100e-07 0.7 1.266000e-07 0.7
+ 1.266100e-07 0 1.304000e-07 0 1.304100e-07 0.7 1.306000e-07 0.7 1.306100e-07 0 1.344000e-07 0
+ 1.344100e-07 0.7 1.346000e-07 0.7 1.346100e-07 0 1.384000e-07 0 1.384100e-07 0.7 1.386000e-07 0.7
+ 1.386100e-07 0 1.424000e-07 0 1.424100e-07 0.7 1.426000e-07 0.7 1.426100e-07 0 1.464000e-07 0
+ 1.464100e-07 0.7 1.466000e-07 0.7 1.466100e-07 0 1.504000e-07 0 1.504100e-07 0.7 1.506000e-07 0.7
+ 1.506100e-07 0 1.544000e-07 0 1.544100e-07 0.7 1.546000e-07 0.7 1.546100e-07 0 1.584000e-07 0
+ 1.584100e-07 0.7 1.586000e-07 0.7 1.586100e-07 0 1.624000e-07 0 1.624100e-07 0.7 1.626000e-07 0.7
+ 1.626100e-07 0 1.664000e-07 0 1.664100e-07 0.7 1.666000e-07 0.7 1.666100e-07 0 1.704000e-07 0
+ 1.704100e-07 0.7 1.706000e-07 0.7 1.706100e-07 0 1.744000e-07 0 1.744100e-07 0.7 1.746000e-07 0.7
+ 1.746100e-07 0 1.784000e-07 0 1.784100e-07 0.7 1.786000e-07 0.7 1.786100e-07 0 1.802000e-07 0
+ 1.802100e-07 0.7 1.820000e-07 0.7 1.820100e-07 0 1.822000e-07 0 1.822100e-07 0.7 1.824000e-07 0.7
+ 1.824100e-07 0 1.826000e-07 0 1.826100e-07 0.7 1.860000e-07 0.7 1.860100e-07 0 1.862000e-07 0
+ 1.862100e-07 0.7 1.864000e-07 0.7 1.864100e-07 0 1.866000e-07 0 1.866100e-07 0.7 1.900000e-07 0.7
+ 1.900100e-07 0 1.902000e-07 0 1.902100e-07 0.7 1.904000e-07 0.7 1.904100e-07 0 1.906000e-07 0
+ 1.906100e-07 0.7 1.940000e-07 0.7 1.940100e-07 0 1.942000e-07 0 1.942100e-07 0.7 1.944000e-07 0.7
+ 1.944100e-07 0 1.946000e-07 0 1.946100e-07 0.7 1.980000e-07 0.7 1.980100e-07 0 1.982000e-07 0
+ 1.982100e-07 0.7 1.984000e-07 0.7 1.984100e-07 0 1.986000e-07 0 1.986100e-07 0.7 2.020000e-07 0.7
+ 2.020100e-07 0 2.022000e-07 0 2.022100e-07 0.7 2.024000e-07 0.7 2.024100e-07 0 2.026000e-07 0
+ 2.026100e-07 0.7 2.060000e-07 0.7 2.060100e-07 0 2.062000e-07 0 2.062100e-07 0.7 2.064000e-07 0.7
+ 2.064100e-07 0 2.066000e-07 0 2.066100e-07 0.7 2.100000e-07 0.7 2.100100e-07 0 2.102000e-07 0
+ 2.102100e-07 0.7 2.104000e-07 0.7 2.104100e-07 0 2.106000e-07 0 2.106100e-07 0.7 2.140000e-07 0.7
+ 2.140100e-07 0 2.142000e-07 0 2.142100e-07 0.7 2.144000e-07 0.7 2.144100e-07 0 2.146000e-07 0
+ 2.146100e-07 0.7 2.162000e-07 0.7 2.162100e-07 0 2.184000e-07 0 2.184100e-07 0.7 2.186000e-07 0.7
+ 2.186100e-07 0 2.224000e-07 0 2.224100e-07 0.7 2.226000e-07 0.7 2.226100e-07 0 2.264000e-07 0
+ 2.264100e-07 0.7 2.266000e-07 0.7 2.266100e-07 0 2.304000e-07 0 2.304100e-07 0.7 2.306000e-07 0.7
+ 2.306100e-07 0 2.344000e-07 0 2.344100e-07 0.7 2.346000e-07 0.7 2.346100e-07 0 2.384000e-07 0
+ 2.384100e-07 0.7 2.386000e-07 0.7 2.386100e-07 0 2.424000e-07 0 2.424100e-07 0.7 2.426000e-07 0.7
+ 2.426100e-07 0 2.464000e-07 0 2.464100e-07 0.7 2.466000e-07 0.7 2.466100e-07 0 2.504000e-07 0
+ 2.504100e-07 0.7 2.506000e-07 0.7 2.506100e-07 0 2.544000e-07 0 2.544100e-07 0.7 2.546000e-07 0.7
+ 2.546100e-07 0 2.584000e-07 0 2.584100e-07 0.7 2.586000e-07 0.7 2.586100e-07 0 2.624000e-07 0
+ 2.624100e-07 0.7 2.626000e-07 0.7 2.626100e-07 0 2.664000e-07 0 2.664100e-07 0.7 2.666000e-07 0.7
+ 2.666100e-07 0 2.704000e-07 0 2.704100e-07 0.7 2.706000e-07 0.7 2.706100e-07 0 2.744000e-07 0
+ 2.744100e-07 0.7 2.746000e-07 0.7 2.746100e-07 0 2.784000e-07 0 2.784100e-07 0.7 2.786000e-07 0.7
+ 2.786100e-07 0 2.824000e-07 0 2.824100e-07 0.7 2.826000e-07 0.7 2.826100e-07 0 2.864000e-07 0
+ 2.864100e-07 0.7 2.866000e-07 0.7 2.866100e-07 0 2.882000e-07 0 2.882100e-07 0.7 2.900000e-07 0.7
+ 2.900100e-07 0 2.902000e-07 0 2.902100e-07 0.7 2.904000e-07 0.7 2.904100e-07 0 2.906000e-07 0
+ 2.906100e-07 0.7 2.940000e-07 0.7 2.940100e-07 0 2.942000e-07 0 2.942100e-07 0.7 2.944000e-07 0.7
+ 2.944100e-07 0 2.946000e-07 0 2.946100e-07 0.7 2.980000e-07 0.7 2.980100e-07 0 2.982000e-07 0
+ 2.982100e-07 0.7 2.984000e-07 0.7 2.984100e-07 0 2.986000e-07 0 2.986100e-07 0.7 3.020000e-07 0.7
+ 3.020100e-07 0 3.022000e-07 0 3.022100e-07 0.7 3.024000e-07 0.7 3.024100e-07 0 3.026000e-07 0
+ 3.026100e-07 0.7 3.060000e-07 0.7 3.060100e-07 0 3.062000e-07 0 3.062100e-07 0.7 3.064000e-07 0.7
+ 3.064100e-07 0 3.066000e-07 0 3.066100e-07 0.7 3.100000e-07 0.7 3.100100e-07 0 3.102000e-07 0
+ 3.102100e-07 0.7 3.104000e-07 0.7 3.104100e-07 0 3.106000e-07 0 3.106100e-07 0.7 3.140000e-07 0.7
+ 3.140100e-07 0 3.142000e-07 0 3.142100e-07 0.7 3.144000e-07 0.7 3.144100e-07 0 3.146000e-07 0
+ 3.146100e-07 0.7 3.180000e-07 0.7 3.180100e-07 0 3.182000e-07 0 3.182100e-07 0.7 3.184000e-07 0.7
+ 3.184100e-07 0 3.186000e-07 0 3.186100e-07 0.7 3.220000e-07 0.7 3.220100e-07 0 3.222000e-07 0
+ 3.222100e-07 0.7 3.224000e-07 0.7 3.224100e-07 0 3.226000e-07 0 3.226100e-07 0.7 3.242000e-07 0.7
+ 3.242100e-07 0 3.264000e-07 0 3.264100e-07 0.7 3.266000e-07 0.7 3.266100e-07 0 3.304000e-07 0
+ 3.304100e-07 0.7 3.306000e-07 0.7 3.306100e-07 0 3.344000e-07 0 3.344100e-07 0.7 3.346000e-07 0.7
+ 3.346100e-07 0 3.384000e-07 0 3.384100e-07 0.7 3.386000e-07 0.7 3.386100e-07 0 3.424000e-07 0
+ 3.424100e-07 0.7 3.426000e-07 0.7 3.426100e-07 0 3.464000e-07 0 3.464100e-07 0.7 3.466000e-07 0.7
+ 3.466100e-07 0 3.504000e-07 0 3.504100e-07 0.7 3.506000e-07 0.7 3.506100e-07 0 3.544000e-07 0
+ 3.544100e-07 0.7 3.546000e-07 0.7 3.546100e-07 0 3.584000e-07 0 3.584100e-07 0.7 3.586000e-07 0.7
+ 3.586100e-07 0 3.624000e-07 0 3.624100e-07 0.7 3.626000e-07 0.7 3.626100e-07 0 3.664000e-07 0
+ 3.664100e-07 0.7 3.666000e-07 0.7 3.666100e-07 0 3.704000e-07 0 3.704100e-07 0.7 3.706000e-07 0.7
+ 3.706100e-07 0 3.744000e-07 0 3.744100e-07 0.7 3.746000e-07 0.7 3.746100e-07 0 3.784000e-07 0
+ 3.784100e-07 0.7 3.786000e-07 0.7 3.786100e-07 0 3.824000e-07 0 3.824100e-07 0.7 3.826000e-07 0.7
+ 3.826100e-07 0 3.864000e-07 0 3.864100e-07 0.7 3.866000e-07 0.7 3.866100e-07 0 3.904000e-07 0
+ 3.904100e-07 0.7 3.906000e-07 0.7 3.906100e-07 0 3.944000e-07 0 3.944100e-07 0.7 3.946000e-07 0.7
+ 3.946100e-07 0 3.962000e-07 0 3.962100e-07 0.7 3.980000e-07 0.7 3.980100e-07 0 3.982000e-07 0
+ 3.982100e-07 0.7 3.984000e-07 0.7 3.984100e-07 0 3.986000e-07 0 3.986100e-07 0.7 4.020000e-07 0.7
+ 4.020100e-07 0 4.022000e-07 0 4.022100e-07 0.7 4.024000e-07 0.7 4.024100e-07 0 4.026000e-07 0
+ 4.026100e-07 0.7 4.060000e-07 0.7 4.060100e-07 0 4.062000e-07 0 4.062100e-07 0.7 4.064000e-07 0.7
+ 4.064100e-07 0 4.066000e-07 0 4.066100e-07 0.7 4.100000e-07 0.7 4.100100e-07 0 4.102000e-07 0
+ 4.102100e-07 0.7 4.104000e-07 0.7 4.104100e-07 0 4.106000e-07 0 4.106100e-07 0.7 4.140000e-07 0.7
+ 4.140100e-07 0 4.142000e-07 0 4.142100e-07 0.7 4.144000e-07 0.7 4.144100e-07 0 4.146000e-07 0
+ 4.146100e-07 0.7 4.180000e-07 0.7 4.180100e-07 0 4.182000e-07 0 4.182100e-07 0.7 4.184000e-07 0.7
+ 4.184100e-07 0 4.186000e-07 0 4.186100e-07 0.7 4.220000e-07 0.7 4.220100e-07 0 4.222000e-07 0
+ 4.222100e-07 0.7 4.224000e-07 0.7 4.224100e-07 0 4.226000e-07 0 4.226100e-07 0.7 4.260000e-07 0.7
+ 4.260100e-07 0 4.262000e-07 0 4.262100e-07 0.7 4.264000e-07 0.7 4.264100e-07 0 4.266000e-07 0
+ 4.266100e-07 0.7 4.300000e-07 0.7 4.300100e-07 0 4.302000e-07 0 4.302100e-07 0.7 4.304000e-07 0.7
+ 4.304100e-07 0 4.306000e-07 0 4.306100e-07 0.7 4.322000e-07 0.7 4.322100e-07 0 4.344000e-07 0
+ 4.344100e-07 0.7 4.346000e-07 0.7 4.346100e-07 0 4.384000e-07 0 4.384100e-07 0.7 4.386000e-07 0.7
+ 4.386100e-07 0 4.424000e-07 0 4.424100e-07 0.7 4.426000e-07 0.7 4.426100e-07 0 4.464000e-07 0
+ 4.464100e-07 0.7 4.466000e-07 0.7 4.466100e-07 0 4.504000e-07 0 4.504100e-07 0.7 4.506000e-07 0.7
+ 4.506100e-07 0 4.544000e-07 0 4.544100e-07 0.7 4.546000e-07 0.7 4.546100e-07 0 4.584000e-07 0
+ 4.584100e-07 0.7 4.586000e-07 0.7 4.586100e-07 0 4.624000e-07 0 4.624100e-07 0.7 4.626000e-07 0.7
+ 4.626100e-07 0 4.664000e-07 0 4.664100e-07 0.7 4.666000e-07 0.7 4.666100e-07 0 4.704000e-07 0
+ 4.704100e-07 0.7 4.706000e-07 0.7 4.706100e-07 0 4.744000e-07 0 4.744100e-07 0.7 4.746000e-07 0.7
+ 4.746100e-07 0 4.784000e-07 0 4.784100e-07 0.7 4.786000e-07 0.7 4.786100e-07 0 4.824000e-07 0
+ 4.824100e-07 0.7 4.826000e-07 0.7 4.826100e-07 0 4.864000e-07 0 4.864100e-07 0.7 4.866000e-07 0.7
+ 4.866100e-07 0 4.904000e-07 0 4.904100e-07 0.7 4.906000e-07 0.7 4.906100e-07 0 4.944000e-07 0
+ 4.944100e-07 0.7 4.946000e-07 0.7 4.946100e-07 0 4.984000e-07 0 4.984100e-07 0.7 4.986000e-07 0.7
+ 4.986100e-07 0 5.024000e-07 0 5.024100e-07 0.7 5.026000e-07 0.7 5.026100e-07 0 5.042000e-07 0
+ 5.042100e-07 0.7 5.060000e-07 0.7 5.060100e-07 0 5.062000e-07 0 5.062100e-07 0.7 5.064000e-07 0.7
+ 5.064100e-07 0 5.066000e-07 0 5.066100e-07 0.7 5.100000e-07 0.7 5.100100e-07 0 5.102000e-07 0
+ 5.102100e-07 0.7 5.104000e-07 0.7 5.104100e-07 0 5.106000e-07 0 5.106100e-07 0.7 5.140000e-07 0.7
+ 5.140100e-07 0 5.142000e-07 0 5.142100e-07 0.7 5.144000e-07 0.7 5.144100e-07 0 5.146000e-07 0
+ 5.146100e-07 0.7 5.180000e-07 0.7 5.180100e-07 0 5.182000e-07 0 5.182100e-07 0.7 5.184000e-07 0.7
+ 5.184100e-07 0 5.186000e-07 0 5.186100e-07 0.7 5.220000e-07 0.7 5.220100e-07 0 5.222000e-07 0
+ 5.222100e-07 0.7 5.224000e-07 0.7 5.224100e-07 0 5.226000e-07 0 5.226100e-07 0.7 5.260000e-07 0.7
+ 5.260100e-07 0 5.262000e-07 0 5.262100e-07 0.7 5.264000e-07 0.7 5.264100e-07 0 5.266000e-07 0
+ 5.266100e-07 0.7 5.300000e-07 0.7 5.300100e-07 0 5.302000e-07 0 5.302100e-07 0.7 5.304000e-07 0.7
+ 5.304100e-07 0 5.306000e-07 0 5.306100e-07 0.7 5.340000e-07 0.7 5.340100e-07 0 5.342000e-07 0
+ 5.342100e-07 0.7 5.344000e-07 0.7 5.344100e-07 0 5.346000e-07 0 5.346100e-07 0.7 5.380000e-07 0.7
+ 5.380100e-07 0 5.382000e-07 0 5.382100e-07 0.7 5.384000e-07 0.7 5.384100e-07 0 5.386000e-07 0
+ 5.386100e-07 0.7 5.402000e-07 0.7 5.402100e-07 0 5.424000e-07 0 5.424100e-07 0.7 5.426000e-07 0.7
+ 5.426100e-07 0 5.464000e-07 0 5.464100e-07 0.7 5.466000e-07 0.7 5.466100e-07 0 5.504000e-07 0
+ 5.504100e-07 0.7 5.506000e-07 0.7 5.506100e-07 0 5.544000e-07 0 5.544100e-07 0.7 5.546000e-07 0.7
+ 5.546100e-07 0 5.584000e-07 0 5.584100e-07 0.7 5.586000e-07 0.7 5.586100e-07 0 5.624000e-07 0
+ 5.624100e-07 0.7 5.626000e-07 0.7 5.626100e-07 0 5.664000e-07 0 5.664100e-07 0.7 5.666000e-07 0.7
+ 5.666100e-07 0 5.704000e-07 0 5.704100e-07 0.7 5.706000e-07 0.7 5.706100e-07 0 5.744000e-07 0
+ 5.744100e-07 0.7 5.746000e-07 0.7 5.746100e-07 0 5.784000e-07 0 5.784100e-07 0.7 5.786000e-07 0.7
+ 5.786100e-07 0 5.824000e-07 0 5.824100e-07 0.7 5.826000e-07 0.7 5.826100e-07 0 5.864000e-07 0
+ 5.864100e-07 0.7 5.866000e-07 0.7 5.866100e-07 0 5.904000e-07 0 5.904100e-07 0.7 5.906000e-07 0.7
+ 5.906100e-07 0 5.944000e-07 0 5.944100e-07 0.7 5.946000e-07 0.7 5.946100e-07 0 5.984000e-07 0
+ 5.984100e-07 0.7 5.986000e-07 0.7 5.986100e-07 0 6.024000e-07 0 6.024100e-07 0.7 6.026000e-07 0.7
+ 6.026100e-07 0 6.064000e-07 0 6.064100e-07 0.7 6.066000e-07 0.7 6.066100e-07 0 6.104000e-07 0
+ 6.104100e-07 0.7 6.106000e-07 0.7 6.106100e-07 0 6.122000e-07 0 6.122100e-07 0.7 6.140000e-07 0.7
+ 6.140100e-07 0 6.142000e-07 0 6.142100e-07 0.7 6.144000e-07 0.7 6.144100e-07 0 6.146000e-07 0
+ 6.146100e-07 0.7 6.180000e-07 0.7 6.180100e-07 0 6.182000e-07 0 6.182100e-07 0.7 6.184000e-07 0.7
+ 6.184100e-07 0 6.186000e-07 0 6.186100e-07 0.7 6.220000e-07 0.7 6.220100e-07 0 6.222000e-07 0
+ 6.222100e-07 0.7 6.224000e-07 0.7 6.224100e-07 0 6.226000e-07 0 6.226100e-07 0.7 6.260000e-07 0.7
+ 6.260100e-07 0 6.262000e-07 0 6.262100e-07 0.7 6.264000e-07 0.7 6.264100e-07 0 6.266000e-07 0
+ 6.266100e-07 0.7 6.300000e-07 0.7 6.300100e-07 0 6.302000e-07 0 6.302100e-07 0.7 6.304000e-07 0.7
+ 6.304100e-07 0 6.306000e-07 0 6.306100e-07 0.7 6.340000e-07 0.7 6.340100e-07 0 6.342000e-07 0
+ 6.342100e-07 0.7 6.344000e-07 0.7 6.344100e-07 0 6.346000e-07 0 6.346100e-07 0.7 6.380000e-07 0.7
+ 6.380100e-07 0 6.382000e-07 0 6.382100e-07 0.7 6.384000e-07 0.7 6.384100e-07 0 6.386000e-07 0
+ 6.386100e-07 0.7 6.420000e-07 0.7 6.420100e-07 0 6.422000e-07 0 6.422100e-07 0.7 6.424000e-07 0.7
+ 6.424100e-07 0 6.426000e-07 0 6.426100e-07 0.7 6.460000e-07 0.7 6.460100e-07 0 6.462000e-07 0
+ 6.462100e-07 0.7 6.464000e-07 0.7 6.464100e-07 0 6.466000e-07 0 6.466100e-07 0.7 6.482000e-07 0.7
+ 6.482100e-07 0 6.504000e-07 0 6.504100e-07 0.7 6.506000e-07 0.7 6.506100e-07 0 6.544000e-07 0
+ 6.544100e-07 0.7 6.546000e-07 0.7 6.546100e-07 0 6.584000e-07 0 6.584100e-07 0.7 6.586000e-07 0.7
+ 6.586100e-07 0 6.624000e-07 0 6.624100e-07 0.7 6.626000e-07 0.7 6.626100e-07 0 6.664000e-07 0
+ 6.664100e-07 0.7 6.666000e-07 0.7 6.666100e-07 0 6.704000e-07 0 6.704100e-07 0.7 6.706000e-07 0.7
+ 6.706100e-07 0 6.744000e-07 0 6.744100e-07 0.7 6.746000e-07 0.7 6.746100e-07 0 6.784000e-07 0
+ 6.784100e-07 0.7 6.786000e-07 0.7 6.786100e-07 0 6.824000e-07 0 6.824100e-07 0.7 6.826000e-07 0.7
+ 6.826100e-07 0 6.864000e-07 0 6.864100e-07 0.7 6.866000e-07 0.7 6.866100e-07 0 6.904000e-07 0
+ 6.904100e-07 0.7 6.906000e-07 0.7 6.906100e-07 0 6.944000e-07 0 6.944100e-07 0.7 6.946000e-07 0.7
+ 6.946100e-07 0 6.984000e-07 0 6.984100e-07 0.7 6.986000e-07 0.7 6.986100e-07 0 7.024000e-07 0
+ 7.024100e-07 0.7 7.026000e-07 0.7 7.026100e-07 0 7.064000e-07 0 7.064100e-07 0.7 7.066000e-07 0.7
+ 7.066100e-07 0 7.104000e-07 0 7.104100e-07 0.7 7.106000e-07 0.7 7.106100e-07 0 7.144000e-07 0
+ 7.144100e-07 0.7 7.146000e-07 0.7 7.146100e-07 0 7.184000e-07 0 7.184100e-07 0.7 7.186000e-07 0.7
+ 7.186100e-07 0 7.202000e-07 0 7.202100e-07 0.7 7.220000e-07 0.7 7.220100e-07 0 7.222000e-07 0
+ 7.222100e-07 0.7 7.224000e-07 0.7 7.224100e-07 0 7.226000e-07 0 7.226100e-07 0.7 7.260000e-07 0.7
+ 7.260100e-07 0 7.262000e-07 0 7.262100e-07 0.7 7.264000e-07 0.7 7.264100e-07 0 7.266000e-07 0
+ 7.266100e-07 0.7 7.300000e-07 0.7 7.300100e-07 0 7.302000e-07 0 7.302100e-07 0.7 7.304000e-07 0.7
+ 7.304100e-07 0 7.306000e-07 0 7.306100e-07 0.7 7.340000e-07 0.7 7.340100e-07 0 7.342000e-07 0
+ 7.342100e-07 0.7 7.344000e-07 0.7 7.344100e-07 0 7.346000e-07 0 7.346100e-07 0.7 7.380000e-07 0.7
+ 7.380100e-07 0 7.382000e-07 0 7.382100e-07 0.7 7.384000e-07 0.7 7.384100e-07 0 7.386000e-07 0
+ 7.386100e-07 0.7 7.420000e-07 0.7 7.420100e-07 0 7.422000e-07 0 7.422100e-07 0.7 7.424000e-07 0.7
+ 7.424100e-07 0 7.426000e-07 0 7.426100e-07 0.7 7.460000e-07 0.7 7.460100e-07 0 7.462000e-07 0
+ 7.462100e-07 0.7 7.464000e-07 0.7 7.464100e-07 0 7.466000e-07 0 7.466100e-07 0.7 7.500000e-07 0.7
+ 7.500100e-07 0 7.502000e-07 0 7.502100e-07 0.7 7.504000e-07 0.7 7.504100e-07 0 7.506000e-07 0
+ 7.506100e-07 0.7 7.540000e-07 0.7 7.540100e-07 0 7.542000e-07 0 7.542100e-07 0.7 7.544000e-07 0.7
+ 7.544100e-07 0 7.546000e-07 0 7.546100e-07 0.7 7.562000e-07 0.7 7.562100e-07 0 7.584000e-07 0
+ 7.584100e-07 0.7 7.586000e-07 0.7 7.586100e-07 0 7.624000e-07 0 7.624100e-07 0.7 7.626000e-07 0.7
+ 7.626100e-07 0 7.664000e-07 0 7.664100e-07 0.7 7.666000e-07 0.7 7.666100e-07 0 7.704000e-07 0
+ 7.704100e-07 0.7 7.706000e-07 0.7 7.706100e-07 0 7.744000e-07 0 7.744100e-07 0.7 7.746000e-07 0.7
+ 7.746100e-07 0 7.784000e-07 0 7.784100e-07 0.7 7.786000e-07 0.7 7.786100e-07 0 7.824000e-07 0
+ 7.824100e-07 0.7 7.826000e-07 0.7 7.826100e-07 0 7.864000e-07 0 7.864100e-07 0.7 7.866000e-07 0.7
+ 7.866100e-07 0 7.904000e-07 0 7.904100e-07 0.7 7.906000e-07 0.7 7.906100e-07 0 7.944000e-07 0
+ 7.944100e-07 0.7 7.946000e-07 0.7 7.946100e-07 0 7.984000e-07 0 7.984100e-07 0.7 7.986000e-07 0.7
+ 7.986100e-07 0 8.024000e-07 0 8.024100e-07 0.7 8.026000e-07 0.7 8.026100e-07 0 8.064000e-07 0
+ 8.064100e-07 0.7 8.066000e-07 0.7 8.066100e-07 0 8.104000e-07 0 8.104100e-07 0.7 8.106000e-07 0.7
+ 8.106100e-07 0 8.144000e-07 0 8.144100e-07 0.7 8.146000e-07 0.7 8.146100e-07 0 8.184000e-07 0
+ 8.184100e-07 0.7 8.186000e-07 0.7 8.186100e-07 0 8.224000e-07 0 8.224100e-07 0.7 8.226000e-07 0.7
+ 8.226100e-07 0 8.264000e-07 0 8.264100e-07 0.7 8.266000e-07 0.7 8.266100e-07 0 8.282000e-07 0
+ 8.282100e-07 0.7 8.300000e-07 0.7 8.300100e-07 0 8.302000e-07 0 8.302100e-07 0.7 8.304000e-07 0.7
+ 8.304100e-07 0 8.306000e-07 0 8.306100e-07 0.7 8.340000e-07 0.7 8.340100e-07 0 8.342000e-07 0
+ 8.342100e-07 0.7 8.344000e-07 0.7 8.344100e-07 0 8.346000e-07 0 8.346100e-07 0.7 8.380000e-07 0.7
+ 8.380100e-07 0 8.382000e-07 0 8.382100e-07 0.7 8.384000e-07 0.7 8.384100e-07 0 8.386000e-07 0
+ 8.386100e-07 0.7 8.420000e-07 0.7 8.420100e-07 0 8.422000e-07 0 8.422100e-07 0.7 8.424000e-07 0.7
+ 8.424100e-07 0 8.426000e-07 0 8.426100e-07 0.7 8.460000e-07 0.7 8.460100e-07 0 8.462000e-07 0
+ 8.462100e-07 0.7 8.464000e-07 0.7 8.464100e-07 0 8.466000e-07 0 8.466100e-07 0.7 8.500000e-07 0.7
+ 8.500100e-07 0 8.502000e-07 0 8.502100e-07 0.7 8.504000e-07 0.7 8.504100e-07 0 8.506000e-07 0
+ 8.506100e-07 0.7 8.540000e-07 0.7 8.540100e-07 0 8.542000e-07 0 8.542100e-07 0.7 8.544000e-07 0.7
+ 8.544100e-07 0 8.546000e-07 0 8.546100e-07 0.7 8.580000e-07 0.7 8.580100e-07 0 8.582000e-07 0
+ 8.582100e-07 0.7 8.584000e-07 0.7 8.584100e-07 0 8.586000e-07 0 8.586100e-07 0.7 8.620000e-07 0.7
+ 8.620100e-07 0 8.622000e-07 0 8.622100e-07 0.7 8.624000e-07 0.7 8.624100e-07 0 8.626000e-07 0
+ 8.626100e-07 0.7 8.642000e-07 0.7 8.642100e-07 0 8.664000e-07 0 8.664100e-07 0.7 8.666000e-07 0.7
+ 8.666100e-07 0 8.704000e-07 0 8.704100e-07 0.7 8.706000e-07 0.7 8.706100e-07 0 8.744000e-07 0
+ 8.744100e-07 0.7 8.746000e-07 0.7 8.746100e-07 0 8.784000e-07 0 8.784100e-07 0.7 8.786000e-07 0.7
+ 8.786100e-07 0 8.824000e-07 0 8.824100e-07 0.7 8.826000e-07 0.7 8.826100e-07 0 8.864000e-07 0
+ 8.864100e-07 0.7 8.866000e-07 0.7 8.866100e-07 0 8.904000e-07 0 8.904100e-07 0.7 8.906000e-07 0.7
+ 8.906100e-07 0 8.944000e-07 0 8.944100e-07 0.7 8.946000e-07 0.7 8.946100e-07 0 8.984000e-07 0
+ 8.984100e-07 0.7 8.986000e-07 0.7 8.986100e-07 0 9.024000e-07 0 9.024100e-07 0.7 9.026000e-07 0.7
+ 9.026100e-07 0 9.064000e-07 0 9.064100e-07 0.7 9.066000e-07 0.7 9.066100e-07 0 9.104000e-07 0
+ 9.104100e-07 0.7 9.106000e-07 0.7 9.106100e-07 0 9.144000e-07 0 9.144100e-07 0.7 9.146000e-07 0.7
+ 9.146100e-07 0 9.184000e-07 0 9.184100e-07 0.7 9.186000e-07 0.7 9.186100e-07 0 9.224000e-07 0
+ 9.224100e-07 0.7 9.226000e-07 0.7 9.226100e-07 0 9.264000e-07 0 9.264100e-07 0.7 9.266000e-07 0.7
+ 9.266100e-07 0 9.304000e-07 0 9.304100e-07 0.7 9.306000e-07 0.7 9.306100e-07 0 9.344000e-07 0
+ 9.344100e-07 0.7 9.346000e-07 0.7 9.346100e-07 0 9.362000e-07 0 9.362100e-07 0.7 9.380000e-07 0.7
+ 9.380100e-07 0 9.382000e-07 0 9.382100e-07 0.7 9.384000e-07 0.7 9.384100e-07 0 9.386000e-07 0
+ 9.386100e-07 0.7 9.420000e-07 0.7 9.420100e-07 0 9.422000e-07 0 9.422100e-07 0.7 9.424000e-07 0.7
+ 9.424100e-07 0 9.426000e-07 0 9.426100e-07 0.7 9.460000e-07 0.7 9.460100e-07 0 9.462000e-07 0
+ 9.462100e-07 0.7 9.464000e-07 0.7 9.464100e-07 0 9.466000e-07 0 9.466100e-07 0.7 9.500000e-07 0.7
+ 9.500100e-07 0 9.502000e-07 0 9.502100e-07 0.7 9.504000e-07 0.7 9.504100e-07 0 9.506000e-07 0
+ 9.506100e-07 0.7 9.540000e-07 0.7 9.540100e-07 0 9.542000e-07 0 9.542100e-07 0.7 9.544000e-07 0.7
+ 9.544100e-07 0 9.546000e-07 0 9.546100e-07 0.7 9.580000e-07 0.7 9.580100e-07 0 9.582000e-07 0
+ 9.582100e-07 0.7 9.584000e-07 0.7 9.584100e-07 0 9.586000e-07 0 9.586100e-07 0.7 9.620000e-07 0.7
+ 9.620100e-07 0 9.622000e-07 0 9.622100e-07 0.7 9.624000e-07 0.7 9.624100e-07 0 9.626000e-07 0
+ 9.626100e-07 0.7 9.660000e-07 0.7 9.660100e-07 0 9.662000e-07 0 9.662100e-07 0.7 9.664000e-07 0.7
+ 9.664100e-07 0 9.666000e-07 0 9.666100e-07 0.7 9.700000e-07 0.7 9.700100e-07 0 9.702000e-07 0
+ 9.702100e-07 0.7 9.704000e-07 0.7 9.704100e-07 0 9.706000e-07 0 9.706100e-07 0.7 )
v_XA0 src_XA0 0 pwl(
+ 0.000000e+00 0 2.800000e-09 0 2.810000e-09 0.7 3.000000e-09 0.7 3.010000e-09 0 3.200000e-09 0
+ 3.210000e-09 0.7 3.400000e-09 0.7 3.410000e-09 0 6.800000e-09 0 6.810000e-09 0.7 7.000000e-09 0.7
+ 7.010000e-09 0 7.200000e-09 0 7.210000e-09 0.7 7.400000e-09 0.7 7.410000e-09 0 1.080000e-08 0
+ 1.081000e-08 0.7 1.100000e-08 0.7 1.101000e-08 0 1.120000e-08 0 1.121000e-08 0.7 1.140000e-08 0.7
+ 1.141000e-08 0 1.220000e-08 0 1.221000e-08 0.7 1.480000e-08 0.7 1.481000e-08 0 1.500000e-08 0
+ 1.501000e-08 0.7 1.880000e-08 0.7 1.881000e-08 0 1.900000e-08 0 1.901000e-08 0.7 2.280000e-08 0.7
+ 2.281000e-08 0 2.300000e-08 0 2.301000e-08 0.7 2.680000e-08 0.7 2.681000e-08 0 2.700000e-08 0
+ 2.701000e-08 0.7 3.080000e-08 0.7 3.081000e-08 0 3.100000e-08 0 3.101000e-08 0.7 3.480000e-08 0.7
+ 3.481000e-08 0 3.500000e-08 0 3.501000e-08 0.7 3.620000e-08 0.7 3.621000e-08 0 3.880000e-08 0
+ 3.881000e-08 0.7 3.900000e-08 0.7 3.901000e-08 0 3.920000e-08 0 3.921000e-08 0.7 3.940000e-08 0.7
+ 3.941000e-08 0 4.280000e-08 0 4.281000e-08 0.7 4.300000e-08 0.7 4.301000e-08 0 4.320000e-08 0
+ 4.321000e-08 0.7 4.340000e-08 0.7 4.341000e-08 0 4.680000e-08 0 4.681000e-08 0.7 4.700000e-08 0.7
+ 4.701000e-08 0 4.720000e-08 0 4.721000e-08 0.7 4.740000e-08 0.7 4.741000e-08 0 4.820000e-08 0
+ 4.821000e-08 0.7 5.080000e-08 0.7 5.081000e-08 0 5.100000e-08 0 5.101000e-08 0.7 5.480000e-08 0.7
+ 5.481000e-08 0 5.500000e-08 0 5.501000e-08 0.7 5.880000e-08 0.7 5.881000e-08 0 5.900000e-08 0
+ 5.901000e-08 0.7 6.280000e-08 0.7 6.281000e-08 0 6.300000e-08 0 6.301000e-08 0.7 6.680000e-08 0.7
+ 6.681000e-08 0 6.700000e-08 0 6.701000e-08 0.7 7.080000e-08 0.7 7.081000e-08 0 7.100000e-08 0
+ 7.101000e-08 0.7 7.220000e-08 0.7 7.221000e-08 0 7.480000e-08 0 7.481000e-08 0.7 7.500000e-08 0.7
+ 7.501000e-08 0 7.520000e-08 0 7.521000e-08 0.7 7.540000e-08 0.7 7.541000e-08 0 7.880000e-08 0
+ 7.881000e-08 0.7 7.900000e-08 0.7 7.901000e-08 0 7.920000e-08 0 7.921000e-08 0.7 7.940000e-08 0.7
+ 7.941000e-08 0 8.280000e-08 0 8.281000e-08 0.7 8.300000e-08 0.7 8.301000e-08 0 8.320000e-08 0
+ 8.321000e-08 0.7 8.340000e-08 0.7 8.341000e-08 0 8.420000e-08 0 8.421000e-08 0.7 8.680000e-08 0.7
+ 8.681000e-08 0 8.700000e-08 0 8.701000e-08 0.7 9.080000e-08 0.7 9.081000e-08 0 9.100000e-08 0
+ 9.101000e-08 0.7 9.480000e-08 0.7 9.481000e-08 0 9.500000e-08 0 9.501000e-08 0.7 9.880000e-08 0.7
+ 9.881000e-08 0 9.900000e-08 0 9.901000e-08 0.7 1.028000e-07 0.7 1.028100e-07 0 1.030000e-07 0
+ 1.030100e-07 0.7 1.068000e-07 0.7 1.068100e-07 0 1.070000e-07 0 1.070100e-07 0.7 1.082000e-07 0.7
+ 1.082100e-07 0 1.108000e-07 0 1.108100e-07 0.7 1.110000e-07 0.7 1.110100e-07 0 1.112000e-07 0
+ 1.112100e-07 0.7 1.114000e-07 0.7 1.114100e-07 0 1.148000e-07 0 1.148100e-07 0.7 1.150000e-07 0.7
+ 1.150100e-07 0 1.152000e-07 0 1.152100e-07 0.7 1.154000e-07 0.7 1.154100e-07 0 1.188000e-07 0
+ 1.188100e-07 0.7 1.190000e-07 0.7 1.190100e-07 0 1.192000e-07 0 1.192100e-07 0.7 1.194000e-07 0.7
+ 1.194100e-07 0 1.202000e-07 0 1.202100e-07 0.7 1.228000e-07 0.7 1.228100e-07 0 1.230000e-07 0
+ 1.230100e-07 0.7 1.268000e-07 0.7 1.268100e-07 0 1.270000e-07 0 1.270100e-07 0.7 1.308000e-07 0.7
+ 1.308100e-07 0 1.310000e-07 0 1.310100e-07 0.7 1.348000e-07 0.7 1.348100e-07 0 1.350000e-07 0
+ 1.350100e-07 0.7 1.388000e-07 0.7 1.388100e-07 0 1.390000e-07 0 1.390100e-07 0.7 1.428000e-07 0.7
+ 1.428100e-07 0 1.430000e-07 0 1.430100e-07 0.7 1.442000e-07 0.7 1.442100e-07 0 1.468000e-07 0
+ 1.468100e-07 0.7 1.470000e-07 0.7 1.470100e-07 0 1.472000e-07 0 1.472100e-07 0.7 1.474000e-07 0.7
+ 1.474100e-07 0 1.508000e-07 0 1.508100e-07 0.7 1.510000e-07 0.7 1.510100e-07 0 1.512000e-07 0
+ 1.512100e-07 0.7 1.514000e-07 0.7 1.514100e-07 0 1.548000e-07 0 1.548100e-07 0.7 1.550000e-07 0.7
+ 1.550100e-07 0 1.552000e-07 0 1.552100e-07 0.7 1.554000e-07 0.7 1.554100e-07 0 1.562000e-07 0
+ 1.562100e-07 0.7 1.588000e-07 0.7 1.588100e-07 0 1.590000e-07 0 1.590100e-07 0.7 1.628000e-07 0.7
+ 1.628100e-07 0 1.630000e-07 0 1.630100e-07 0.7 1.668000e-07 0.7 1.668100e-07 0 1.670000e-07 0
+ 1.670100e-07 0.7 1.708000e-07 0.7 1.708100e-07 0 1.710000e-07 0 1.710100e-07 0.7 1.748000e-07 0.7
+ 1.748100e-07 0 1.750000e-07 0 1.750100e-07 0.7 1.788000e-07 0.7 1.788100e-07 0 1.790000e-07 0
+ 1.790100e-07 0.7 1.802000e-07 0.7 1.802100e-07 0 1.828000e-07 0 1.828100e-07 0.7 1.830000e-07 0.7
+ 1.830100e-07 0 1.832000e-07 0 1.832100e-07 0.7 1.834000e-07 0.7 1.834100e-07 0 1.868000e-07 0
+ 1.868100e-07 0.7 1.870000e-07 0.7 1.870100e-07 0 1.872000e-07 0 1.872100e-07 0.7 1.874000e-07 0.7
+ 1.874100e-07 0 1.908000e-07 0 1.908100e-07 0.7 1.910000e-07 0.7 1.910100e-07 0 1.912000e-07 0
+ 1.912100e-07 0.7 1.914000e-07 0.7 1.914100e-07 0 1.922000e-07 0 1.922100e-07 0.7 1.948000e-07 0.7
+ 1.948100e-07 0 1.950000e-07 0 1.950100e-07 0.7 1.988000e-07 0.7 1.988100e-07 0 1.990000e-07 0
+ 1.990100e-07 0.7 2.028000e-07 0.7 2.028100e-07 0 2.030000e-07 0 2.030100e-07 0.7 2.068000e-07 0.7
+ 2.068100e-07 0 2.070000e-07 0 2.070100e-07 0.7 2.108000e-07 0.7 2.108100e-07 0 2.110000e-07 0
+ 2.110100e-07 0.7 2.148000e-07 0.7 2.148100e-07 0 2.150000e-07 0 2.150100e-07 0.7 2.162000e-07 0.7
+ 2.162100e-07 0 2.188000e-07 0 2.188100e-07 0.7 2.190000e-07 0.7 2.190100e-07 0 2.192000e-07 0
+ 2.192100e-07 0.7 2.194000e-07 0.7 2.194100e-07 0 2.228000e-07 0 2.228100e-07 0.7 2.230000e-07 0.7
+ 2.230100e-07 0 2.232000e-07 0 2.232100e-07 0.7 2.234000e-07 0.7 2.234100e-07 0 2.268000e-07 0
+ 2.268100e-07 0.7 2.270000e-07 0.7 2.270100e-07 0 2.272000e-07 0 2.272100e-07 0.7 2.274000e-07 0.7
+ 2.274100e-07 0 2.282000e-07 0 2.282100e-07 0.7 2.308000e-07 0.7 2.308100e-07 0 2.310000e-07 0
+ 2.310100e-07 0.7 2.348000e-07 0.7 2.348100e-07 0 2.350000e-07 0 2.350100e-07 0.7 2.388000e-07 0.7
+ 2.388100e-07 0 2.390000e-07 0 2.390100e-07 0.7 2.428000e-07 0.7 2.428100e-07 0 2.430000e-07 0
+ 2.430100e-07 0.7 2.468000e-07 0.7 2.468100e-07 0 2.470000e-07 0 2.470100e-07 0.7 2.508000e-07 0.7
+ 2.508100e-07 0 2.510000e-07 0 2.510100e-07 0.7 2.522000e-07 0.7 2.522100e-07 0 2.548000e-07 0
+ 2.548100e-07 0.7 2.550000e-07 0.7 2.550100e-07 0 2.552000e-07 0 2.552100e-07 0.7 2.554000e-07 0.7
+ 2.554100e-07 0 2.588000e-07 0 2.588100e-07 0.7 2.590000e-07 0.7 2.590100e-07 0 2.592000e-07 0
+ 2.592100e-07 0.7 2.594000e-07 0.7 2.594100e-07 0 2.628000e-07 0 2.628100e-07 0.7 2.630000e-07 0.7
+ 2.630100e-07 0 2.632000e-07 0 2.632100e-07 0.7 2.634000e-07 0.7 2.634100e-07 0 2.642000e-07 0
+ 2.642100e-07 0.7 2.668000e-07 0.7 2.668100e-07 0 2.670000e-07 0 2.670100e-07 0.7 2.708000e-07 0.7
+ 2.708100e-07 0 2.710000e-07 0 2.710100e-07 0.7 2.748000e-07 0.7 2.748100e-07 0 2.750000e-07 0
+ 2.750100e-07 0.7 2.788000e-07 0.7 2.788100e-07 0 2.790000e-07 0 2.790100e-07 0.7 2.828000e-07 0.7
+ 2.828100e-07 0 2.830000e-07 0 2.830100e-07 0.7 2.868000e-07 0.7 2.868100e-07 0 2.870000e-07 0
+ 2.870100e-07 0.7 2.882000e-07 0.7 2.882100e-07 0 2.908000e-07 0 2.908100e-07 0.7 2.910000e-07 0.7
+ 2.910100e-07 0 2.912000e-07 0 2.912100e-07 0.7 2.914000e-07 0.7 2.914100e-07 0 2.948000e-07 0
+ 2.948100e-07 0.7 2.950000e-07 0.7 2.950100e-07 0 2.952000e-07 0 2.952100e-07 0.7 2.954000e-07 0.7
+ 2.954100e-07 0 2.988000e-07 0 2.988100e-07 0.7 2.990000e-07 0.7 2.990100e-07 0 2.992000e-07 0
+ 2.992100e-07 0.7 2.994000e-07 0.7 2.994100e-07 0 3.002000e-07 0 3.002100e-07 0.7 3.028000e-07 0.7
+ 3.028100e-07 0 3.030000e-07 0 3.030100e-07 0.7 3.068000e-07 0.7 3.068100e-07 0 3.070000e-07 0
+ 3.070100e-07 0.7 3.108000e-07 0.7 3.108100e-07 0 3.110000e-07 0 3.110100e-07 0.7 3.148000e-07 0.7
+ 3.148100e-07 0 3.150000e-07 0 3.150100e-07 0.7 3.188000e-07 0.7 3.188100e-07 0 3.190000e-07 0
+ 3.190100e-07 0.7 3.228000e-07 0.7 3.228100e-07 0 3.230000e-07 0 3.230100e-07 0.7 3.242000e-07 0.7
+ 3.242100e-07 0 3.268000e-07 0 3.268100e-07 0.7 3.270000e-07 0.7 3.270100e-07 0 3.272000e-07 0
+ 3.272100e-07 0.7 3.274000e-07 0.7 3.274100e-07 0 3.308000e-07 0 3.308100e-07 0.7 3.310000e-07 0.7
+ 3.310100e-07 0 3.312000e-07 0 3.312100e-07 0.7 3.314000e-07 0.7 3.314100e-07 0 3.348000e-07 0
+ 3.348100e-07 0.7 3.350000e-07 0.7 3.350100e-07 0 3.352000e-07 0 3.352100e-07 0.7 3.354000e-07 0.7
+ 3.354100e-07 0 3.362000e-07 0 3.362100e-07 0.7 3.388000e-07 0.7 3.388100e-07 0 3.390000e-07 0
+ 3.390100e-07 0.7 3.428000e-07 0.7 3.428100e-07 0 3.430000e-07 0 3.430100e-07 0.7 3.468000e-07 0.7
+ 3.468100e-07 0 3.470000e-07 0 3.470100e-07 0.7 3.508000e-07 0.7 3.508100e-07 0 3.510000e-07 0
+ 3.510100e-07 0.7 3.548000e-07 0.7 3.548100e-07 0 3.550000e-07 0 3.550100e-07 0.7 3.588000e-07 0.7
+ 3.588100e-07 0 3.590000e-07 0 3.590100e-07 0.7 3.602000e-07 0.7 3.602100e-07 0 3.628000e-07 0
+ 3.628100e-07 0.7 3.630000e-07 0.7 3.630100e-07 0 3.632000e-07 0 3.632100e-07 0.7 3.634000e-07 0.7
+ 3.634100e-07 0 3.668000e-07 0 3.668100e-07 0.7 3.670000e-07 0.7 3.670100e-07 0 3.672000e-07 0
+ 3.672100e-07 0.7 3.674000e-07 0.7 3.674100e-07 0 3.708000e-07 0 3.708100e-07 0.7 3.710000e-07 0.7
+ 3.710100e-07 0 3.712000e-07 0 3.712100e-07 0.7 3.714000e-07 0.7 3.714100e-07 0 3.722000e-07 0
+ 3.722100e-07 0.7 3.748000e-07 0.7 3.748100e-07 0 3.750000e-07 0 3.750100e-07 0.7 3.788000e-07 0.7
+ 3.788100e-07 0 3.790000e-07 0 3.790100e-07 0.7 3.828000e-07 0.7 3.828100e-07 0 3.830000e-07 0
+ 3.830100e-07 0.7 3.868000e-07 0.7 3.868100e-07 0 3.870000e-07 0 3.870100e-07 0.7 3.908000e-07 0.7
+ 3.908100e-07 0 3.910000e-07 0 3.910100e-07 0.7 3.948000e-07 0.7 3.948100e-07 0 3.950000e-07 0
+ 3.950100e-07 0.7 3.962000e-07 0.7 3.962100e-07 0 3.988000e-07 0 3.988100e-07 0.7 3.990000e-07 0.7
+ 3.990100e-07 0 3.992000e-07 0 3.992100e-07 0.7 3.994000e-07 0.7 3.994100e-07 0 4.028000e-07 0
+ 4.028100e-07 0.7 4.030000e-07 0.7 4.030100e-07 0 4.032000e-07 0 4.032100e-07 0.7 4.034000e-07 0.7
+ 4.034100e-07 0 4.068000e-07 0 4.068100e-07 0.7 4.070000e-07 0.7 4.070100e-07 0 4.072000e-07 0
+ 4.072100e-07 0.7 4.074000e-07 0.7 4.074100e-07 0 4.082000e-07 0 4.082100e-07 0.7 4.108000e-07 0.7
+ 4.108100e-07 0 4.110000e-07 0 4.110100e-07 0.7 4.148000e-07 0.7 4.148100e-07 0 4.150000e-07 0
+ 4.150100e-07 0.7 4.188000e-07 0.7 4.188100e-07 0 4.190000e-07 0 4.190100e-07 0.7 4.228000e-07 0.7
+ 4.228100e-07 0 4.230000e-07 0 4.230100e-07 0.7 4.268000e-07 0.7 4.268100e-07 0 4.270000e-07 0
+ 4.270100e-07 0.7 4.308000e-07 0.7 4.308100e-07 0 4.310000e-07 0 4.310100e-07 0.7 4.322000e-07 0.7
+ 4.322100e-07 0 4.348000e-07 0 4.348100e-07 0.7 4.350000e-07 0.7 4.350100e-07 0 4.352000e-07 0
+ 4.352100e-07 0.7 4.354000e-07 0.7 4.354100e-07 0 4.388000e-07 0 4.388100e-07 0.7 4.390000e-07 0.7
+ 4.390100e-07 0 4.392000e-07 0 4.392100e-07 0.7 4.394000e-07 0.7 4.394100e-07 0 4.428000e-07 0
+ 4.428100e-07 0.7 4.430000e-07 0.7 4.430100e-07 0 4.432000e-07 0 4.432100e-07 0.7 4.434000e-07 0.7
+ 4.434100e-07 0 4.442000e-07 0 4.442100e-07 0.7 4.468000e-07 0.7 4.468100e-07 0 4.470000e-07 0
+ 4.470100e-07 0.7 4.508000e-07 0.7 4.508100e-07 0 4.510000e-07 0 4.510100e-07 0.7 4.548000e-07 0.7
+ 4.548100e-07 0 4.550000e-07 0 4.550100e-07 0.7 4.588000e-07 0.7 4.588100e-07 0 4.590000e-07 0
+ 4.590100e-07 0.7 4.628000e-07 0.7 4.628100e-07 0 4.630000e-07 0 4.630100e-07 0.7 4.668000e-07 0.7
+ 4.668100e-07 0 4.670000e-07 0 4.670100e-07 0.7 4.682000e-07 0.7 4.682100e-07 0 4.708000e-07 0
+ 4.708100e-07 0.7 4.710000e-07 0.7 4.710100e-07 0 4.712000e-07 0 4.712100e-07 0.7 4.714000e-07 0.7
+ 4.714100e-07 0 4.748000e-07 0 4.748100e-07 0.7 4.750000e-07 0.7 4.750100e-07 0 4.752000e-07 0
+ 4.752100e-07 0.7 4.754000e-07 0.7 4.754100e-07 0 4.788000e-07 0 4.788100e-07 0.7 4.790000e-07 0.7
+ 4.790100e-07 0 4.792000e-07 0 4.792100e-07 0.7 4.794000e-07 0.7 4.794100e-07 0 4.802000e-07 0
+ 4.802100e-07 0.7 4.828000e-07 0.7 4.828100e-07 0 4.830000e-07 0 4.830100e-07 0.7 4.868000e-07 0.7
+ 4.868100e-07 0 4.870000e-07 0 4.870100e-07 0.7 4.908000e-07 0.7 4.908100e-07 0 4.910000e-07 0
+ 4.910100e-07 0.7 4.948000e-07 0.7 4.948100e-07 0 4.950000e-07 0 4.950100e-07 0.7 4.988000e-07 0.7
+ 4.988100e-07 0 4.990000e-07 0 4.990100e-07 0.7 5.028000e-07 0.7 5.028100e-07 0 5.030000e-07 0
+ 5.030100e-07 0.7 5.042000e-07 0.7 5.042100e-07 0 5.068000e-07 0 5.068100e-07 0.7 5.070000e-07 0.7
+ 5.070100e-07 0 5.072000e-07 0 5.072100e-07 0.7 5.074000e-07 0.7 5.074100e-07 0 5.108000e-07 0
+ 5.108100e-07 0.7 5.110000e-07 0.7 5.110100e-07 0 5.112000e-07 0 5.112100e-07 0.7 5.114000e-07 0.7
+ 5.114100e-07 0 5.148000e-07 0 5.148100e-07 0.7 5.150000e-07 0.7 5.150100e-07 0 5.152000e-07 0
+ 5.152100e-07 0.7 5.154000e-07 0.7 5.154100e-07 0 5.162000e-07 0 5.162100e-07 0.7 5.188000e-07 0.7
+ 5.188100e-07 0 5.190000e-07 0 5.190100e-07 0.7 5.228000e-07 0.7 5.228100e-07 0 5.230000e-07 0
+ 5.230100e-07 0.7 5.268000e-07 0.7 5.268100e-07 0 5.270000e-07 0 5.270100e-07 0.7 5.308000e-07 0.7
+ 5.308100e-07 0 5.310000e-07 0 5.310100e-07 0.7 5.348000e-07 0.7 5.348100e-07 0 5.350000e-07 0
+ 5.350100e-07 0.7 5.388000e-07 0.7 5.388100e-07 0 5.390000e-07 0 5.390100e-07 0.7 5.402000e-07 0.7
+ 5.402100e-07 0 5.428000e-07 0 5.428100e-07 0.7 5.430000e-07 0.7 5.430100e-07 0 5.432000e-07 0
+ 5.432100e-07 0.7 5.434000e-07 0.7 5.434100e-07 0 5.468000e-07 0 5.468100e-07 0.7 5.470000e-07 0.7
+ 5.470100e-07 0 5.472000e-07 0 5.472100e-07 0.7 5.474000e-07 0.7 5.474100e-07 0 5.508000e-07 0
+ 5.508100e-07 0.7 5.510000e-07 0.7 5.510100e-07 0 5.512000e-07 0 5.512100e-07 0.7 5.514000e-07 0.7
+ 5.514100e-07 0 5.522000e-07 0 5.522100e-07 0.7 5.548000e-07 0.7 5.548100e-07 0 5.550000e-07 0
+ 5.550100e-07 0.7 5.588000e-07 0.7 5.588100e-07 0 5.590000e-07 0 5.590100e-07 0.7 5.628000e-07 0.7
+ 5.628100e-07 0 5.630000e-07 0 5.630100e-07 0.7 5.668000e-07 0.7 5.668100e-07 0 5.670000e-07 0
+ 5.670100e-07 0.7 5.708000e-07 0.7 5.708100e-07 0 5.710000e-07 0 5.710100e-07 0.7 5.748000e-07 0.7
+ 5.748100e-07 0 5.750000e-07 0 5.750100e-07 0.7 5.762000e-07 0.7 5.762100e-07 0 5.788000e-07 0
+ 5.788100e-07 0.7 5.790000e-07 0.7 5.790100e-07 0 5.792000e-07 0 5.792100e-07 0.7 5.794000e-07 0.7
+ 5.794100e-07 0 5.828000e-07 0 5.828100e-07 0.7 5.830000e-07 0.7 5.830100e-07 0 5.832000e-07 0
+ 5.832100e-07 0.7 5.834000e-07 0.7 5.834100e-07 0 5.868000e-07 0 5.868100e-07 0.7 5.870000e-07 0.7
+ 5.870100e-07 0 5.872000e-07 0 5.872100e-07 0.7 5.874000e-07 0.7 5.874100e-07 0 5.882000e-07 0
+ 5.882100e-07 0.7 5.908000e-07 0.7 5.908100e-07 0 5.910000e-07 0 5.910100e-07 0.7 5.948000e-07 0.7
+ 5.948100e-07 0 5.950000e-07 0 5.950100e-07 0.7 5.988000e-07 0.7 5.988100e-07 0 5.990000e-07 0
+ 5.990100e-07 0.7 6.028000e-07 0.7 6.028100e-07 0 6.030000e-07 0 6.030100e-07 0.7 6.068000e-07 0.7
+ 6.068100e-07 0 6.070000e-07 0 6.070100e-07 0.7 6.108000e-07 0.7 6.108100e-07 0 6.110000e-07 0
+ 6.110100e-07 0.7 6.122000e-07 0.7 6.122100e-07 0 6.148000e-07 0 6.148100e-07 0.7 6.150000e-07 0.7
+ 6.150100e-07 0 6.152000e-07 0 6.152100e-07 0.7 6.154000e-07 0.7 6.154100e-07 0 6.188000e-07 0
+ 6.188100e-07 0.7 6.190000e-07 0.7 6.190100e-07 0 6.192000e-07 0 6.192100e-07 0.7 6.194000e-07 0.7
+ 6.194100e-07 0 6.228000e-07 0 6.228100e-07 0.7 6.230000e-07 0.7 6.230100e-07 0 6.232000e-07 0
+ 6.232100e-07 0.7 6.234000e-07 0.7 6.234100e-07 0 6.242000e-07 0 6.242100e-07 0.7 6.268000e-07 0.7
+ 6.268100e-07 0 6.270000e-07 0 6.270100e-07 0.7 6.308000e-07 0.7 6.308100e-07 0 6.310000e-07 0
+ 6.310100e-07 0.7 6.348000e-07 0.7 6.348100e-07 0 6.350000e-07 0 6.350100e-07 0.7 6.388000e-07 0.7
+ 6.388100e-07 0 6.390000e-07 0 6.390100e-07 0.7 6.428000e-07 0.7 6.428100e-07 0 6.430000e-07 0
+ 6.430100e-07 0.7 6.468000e-07 0.7 6.468100e-07 0 6.470000e-07 0 6.470100e-07 0.7 6.482000e-07 0.7
+ 6.482100e-07 0 6.508000e-07 0 6.508100e-07 0.7 6.510000e-07 0.7 6.510100e-07 0 6.512000e-07 0
+ 6.512100e-07 0.7 6.514000e-07 0.7 6.514100e-07 0 6.548000e-07 0 6.548100e-07 0.7 6.550000e-07 0.7
+ 6.550100e-07 0 6.552000e-07 0 6.552100e-07 0.7 6.554000e-07 0.7 6.554100e-07 0 6.588000e-07 0
+ 6.588100e-07 0.7 6.590000e-07 0.7 6.590100e-07 0 6.592000e-07 0 6.592100e-07 0.7 6.594000e-07 0.7
+ 6.594100e-07 0 6.602000e-07 0 6.602100e-07 0.7 6.628000e-07 0.7 6.628100e-07 0 6.630000e-07 0
+ 6.630100e-07 0.7 6.668000e-07 0.7 6.668100e-07 0 6.670000e-07 0 6.670100e-07 0.7 6.708000e-07 0.7
+ 6.708100e-07 0 6.710000e-07 0 6.710100e-07 0.7 6.748000e-07 0.7 6.748100e-07 0 6.750000e-07 0
+ 6.750100e-07 0.7 6.788000e-07 0.7 6.788100e-07 0 6.790000e-07 0 6.790100e-07 0.7 6.828000e-07 0.7
+ 6.828100e-07 0 6.830000e-07 0 6.830100e-07 0.7 6.842000e-07 0.7 6.842100e-07 0 6.868000e-07 0
+ 6.868100e-07 0.7 6.870000e-07 0.7 6.870100e-07 0 6.872000e-07 0 6.872100e-07 0.7 6.874000e-07 0.7
+ 6.874100e-07 0 6.908000e-07 0 6.908100e-07 0.7 6.910000e-07 0.7 6.910100e-07 0 6.912000e-07 0
+ 6.912100e-07 0.7 6.914000e-07 0.7 6.914100e-07 0 6.948000e-07 0 6.948100e-07 0.7 6.950000e-07 0.7
+ 6.950100e-07 0 6.952000e-07 0 6.952100e-07 0.7 6.954000e-07 0.7 6.954100e-07 0 6.962000e-07 0
+ 6.962100e-07 0.7 6.988000e-07 0.7 6.988100e-07 0 6.990000e-07 0 6.990100e-07 0.7 7.028000e-07 0.7
+ 7.028100e-07 0 7.030000e-07 0 7.030100e-07 0.7 7.068000e-07 0.7 7.068100e-07 0 7.070000e-07 0
+ 7.070100e-07 0.7 7.108000e-07 0.7 7.108100e-07 0 7.110000e-07 0 7.110100e-07 0.7 7.148000e-07 0.7
+ 7.148100e-07 0 7.150000e-07 0 7.150100e-07 0.7 7.188000e-07 0.7 7.188100e-07 0 7.190000e-07 0
+ 7.190100e-07 0.7 7.202000e-07 0.7 7.202100e-07 0 7.228000e-07 0 7.228100e-07 0.7 7.230000e-07 0.7
+ 7.230100e-07 0 7.232000e-07 0 7.232100e-07 0.7 7.234000e-07 0.7 7.234100e-07 0 7.268000e-07 0
+ 7.268100e-07 0.7 7.270000e-07 0.7 7.270100e-07 0 7.272000e-07 0 7.272100e-07 0.7 7.274000e-07 0.7
+ 7.274100e-07 0 7.308000e-07 0 7.308100e-07 0.7 7.310000e-07 0.7 7.310100e-07 0 7.312000e-07 0
+ 7.312100e-07 0.7 7.314000e-07 0.7 7.314100e-07 0 7.322000e-07 0 7.322100e-07 0.7 7.348000e-07 0.7
+ 7.348100e-07 0 7.350000e-07 0 7.350100e-07 0.7 7.388000e-07 0.7 7.388100e-07 0 7.390000e-07 0
+ 7.390100e-07 0.7 7.428000e-07 0.7 7.428100e-07 0 7.430000e-07 0 7.430100e-07 0.7 7.468000e-07 0.7
+ 7.468100e-07 0 7.470000e-07 0 7.470100e-07 0.7 7.508000e-07 0.7 7.508100e-07 0 7.510000e-07 0
+ 7.510100e-07 0.7 7.548000e-07 0.7 7.548100e-07 0 7.550000e-07 0 7.550100e-07 0.7 7.562000e-07 0.7
+ 7.562100e-07 0 7.588000e-07 0 7.588100e-07 0.7 7.590000e-07 0.7 7.590100e-07 0 7.592000e-07 0
+ 7.592100e-07 0.7 7.594000e-07 0.7 7.594100e-07 0 7.628000e-07 0 7.628100e-07 0.7 7.630000e-07 0.7
+ 7.630100e-07 0 7.632000e-07 0 7.632100e-07 0.7 7.634000e-07 0.7 7.634100e-07 0 7.668000e-07 0
+ 7.668100e-07 0.7 7.670000e-07 0.7 7.670100e-07 0 7.672000e-07 0 7.672100e-07 0.7 7.674000e-07 0.7
+ 7.674100e-07 0 7.682000e-07 0 7.682100e-07 0.7 7.708000e-07 0.7 7.708100e-07 0 7.710000e-07 0
+ 7.710100e-07 0.7 7.748000e-07 0.7 7.748100e-07 0 7.750000e-07 0 7.750100e-07 0.7 7.788000e-07 0.7
+ 7.788100e-07 0 7.790000e-07 0 7.790100e-07 0.7 7.828000e-07 0.7 7.828100e-07 0 7.830000e-07 0
+ 7.830100e-07 0.7 7.868000e-07 0.7 7.868100e-07 0 7.870000e-07 0 7.870100e-07 0.7 7.908000e-07 0.7
+ 7.908100e-07 0 7.910000e-07 0 7.910100e-07 0.7 7.922000e-07 0.7 7.922100e-07 0 7.948000e-07 0
+ 7.948100e-07 0.7 7.950000e-07 0.7 7.950100e-07 0 7.952000e-07 0 7.952100e-07 0.7 7.954000e-07 0.7
+ 7.954100e-07 0 7.988000e-07 0 7.988100e-07 0.7 7.990000e-07 0.7 7.990100e-07 0 7.992000e-07 0
+ 7.992100e-07 0.7 7.994000e-07 0.7 7.994100e-07 0 8.028000e-07 0 8.028100e-07 0.7 8.030000e-07 0.7
+ 8.030100e-07 0 8.032000e-07 0 8.032100e-07 0.7 8.034000e-07 0.7 8.034100e-07 0 8.042000e-07 0
+ 8.042100e-07 0.7 8.068000e-07 0.7 8.068100e-07 0 8.070000e-07 0 8.070100e-07 0.7 8.108000e-07 0.7
+ 8.108100e-07 0 8.110000e-07 0 8.110100e-07 0.7 8.148000e-07 0.7 8.148100e-07 0 8.150000e-07 0
+ 8.150100e-07 0.7 8.188000e-07 0.7 8.188100e-07 0 8.190000e-07 0 8.190100e-07 0.7 8.228000e-07 0.7
+ 8.228100e-07 0 8.230000e-07 0 8.230100e-07 0.7 8.268000e-07 0.7 8.268100e-07 0 8.270000e-07 0
+ 8.270100e-07 0.7 8.282000e-07 0.7 8.282100e-07 0 8.308000e-07 0 8.308100e-07 0.7 8.310000e-07 0.7
+ 8.310100e-07 0 8.312000e-07 0 8.312100e-07 0.7 8.314000e-07 0.7 8.314100e-07 0 8.348000e-07 0
+ 8.348100e-07 0.7 8.350000e-07 0.7 8.350100e-07 0 8.352000e-07 0 8.352100e-07 0.7 8.354000e-07 0.7
+ 8.354100e-07 0 8.388000e-07 0 8.388100e-07 0.7 8.390000e-07 0.7 8.390100e-07 0 8.392000e-07 0
+ 8.392100e-07 0.7 8.394000e-07 0.7 8.394100e-07 0 8.402000e-07 0 8.402100e-07 0.7 8.428000e-07 0.7
+ 8.428100e-07 0 8.430000e-07 0 8.430100e-07 0.7 8.468000e-07 0.7 8.468100e-07 0 8.470000e-07 0
+ 8.470100e-07 0.7 8.508000e-07 0.7 8.508100e-07 0 8.510000e-07 0 8.510100e-07 0.7 8.548000e-07 0.7
+ 8.548100e-07 0 8.550000e-07 0 8.550100e-07 0.7 8.588000e-07 0.7 8.588100e-07 0 8.590000e-07 0
+ 8.590100e-07 0.7 8.628000e-07 0.7 8.628100e-07 0 8.630000e-07 0 8.630100e-07 0.7 8.642000e-07 0.7
+ 8.642100e-07 0 8.668000e-07 0 8.668100e-07 0.7 8.670000e-07 0.7 8.670100e-07 0 8.672000e-07 0
+ 8.672100e-07 0.7 8.674000e-07 0.7 8.674100e-07 0 8.708000e-07 0 8.708100e-07 0.7 8.710000e-07 0.7
+ 8.710100e-07 0 8.712000e-07 0 8.712100e-07 0.7 8.714000e-07 0.7 8.714100e-07 0 8.748000e-07 0
+ 8.748100e-07 0.7 8.750000e-07 0.7 8.750100e-07 0 8.752000e-07 0 8.752100e-07 0.7 8.754000e-07 0.7
+ 8.754100e-07 0 8.762000e-07 0 8.762100e-07 0.7 8.788000e-07 0.7 8.788100e-07 0 8.790000e-07 0
+ 8.790100e-07 0.7 8.828000e-07 0.7 8.828100e-07 0 8.830000e-07 0 8.830100e-07 0.7 8.868000e-07 0.7
+ 8.868100e-07 0 8.870000e-07 0 8.870100e-07 0.7 8.908000e-07 0.7 8.908100e-07 0 8.910000e-07 0
+ 8.910100e-07 0.7 8.948000e-07 0.7 8.948100e-07 0 8.950000e-07 0 8.950100e-07 0.7 8.988000e-07 0.7
+ 8.988100e-07 0 8.990000e-07 0 8.990100e-07 0.7 9.002000e-07 0.7 9.002100e-07 0 9.028000e-07 0
+ 9.028100e-07 0.7 9.030000e-07 0.7 9.030100e-07 0 9.032000e-07 0 9.032100e-07 0.7 9.034000e-07 0.7
+ 9.034100e-07 0 9.068000e-07 0 9.068100e-07 0.7 9.070000e-07 0.7 9.070100e-07 0 9.072000e-07 0
+ 9.072100e-07 0.7 9.074000e-07 0.7 9.074100e-07 0 9.108000e-07 0 9.108100e-07 0.7 9.110000e-07 0.7
+ 9.110100e-07 0 9.112000e-07 0 9.112100e-07 0.7 9.114000e-07 0.7 9.114100e-07 0 9.122000e-07 0
+ 9.122100e-07 0.7 9.148000e-07 0.7 9.148100e-07 0 9.150000e-07 0 9.150100e-07 0.7 9.188000e-07 0.7
+ 9.188100e-07 0 9.190000e-07 0 9.190100e-07 0.7 9.228000e-07 0.7 9.228100e-07 0 9.230000e-07 0
+ 9.230100e-07 0.7 9.268000e-07 0.7 9.268100e-07 0 9.270000e-07 0 9.270100e-07 0.7 9.308000e-07 0.7
+ 9.308100e-07 0 9.310000e-07 0 9.310100e-07 0.7 9.348000e-07 0.7 9.348100e-07 0 9.350000e-07 0
+ 9.350100e-07 0.7 9.362000e-07 0.7 9.362100e-07 0 9.388000e-07 0 9.388100e-07 0.7 9.390000e-07 0.7
+ 9.390100e-07 0 9.392000e-07 0 9.392100e-07 0.7 9.394000e-07 0.7 9.394100e-07 0 9.428000e-07 0
+ 9.428100e-07 0.7 9.430000e-07 0.7 9.430100e-07 0 9.432000e-07 0 9.432100e-07 0.7 9.434000e-07 0.7
+ 9.434100e-07 0 9.468000e-07 0 9.468100e-07 0.7 9.470000e-07 0.7 9.470100e-07 0 9.472000e-07 0
+ 9.472100e-07 0.7 9.474000e-07 0.7 9.474100e-07 0 9.482000e-07 0 9.482100e-07 0.7 9.508000e-07 0.7
+ 9.508100e-07 0 9.510000e-07 0 9.510100e-07 0.7 9.548000e-07 0.7 9.548100e-07 0 9.550000e-07 0
+ 9.550100e-07 0.7 9.588000e-07 0.7 9.588100e-07 0 9.590000e-07 0 9.590100e-07 0.7 9.628000e-07 0.7
+ 9.628100e-07 0 9.630000e-07 0 9.630100e-07 0.7 9.668000e-07 0.7 9.668100e-07 0 9.670000e-07 0
+ 9.670100e-07 0.7 9.708000e-07 0.7 9.708100e-07 0 9.710000e-07 0 9.710100e-07 0.7 )
v_XA1 src_XA1 0 pwl(
+ 0.000000e+00 0 3.200000e-09 0 3.210000e-09 0.7 3.400000e-09 0.7 3.410000e-09 0 7.200000e-09 0
+ 7.210000e-09 0.7 7.400000e-09 0.7 7.410000e-09 0 1.120000e-08 0 1.121000e-08 0.7 1.140000e-08 0.7
+ 1.141000e-08 0 1.520000e-08 0 1.521000e-08 0.7 1.540000e-08 0.7 1.541000e-08 0 1.920000e-08 0
+ 1.921000e-08 0.7 1.940000e-08 0.7 1.941000e-08 0 2.320000e-08 0 2.321000e-08 0.7 2.340000e-08 0.7
+ 2.341000e-08 0 2.420000e-08 0 2.421000e-08 0.7 2.680000e-08 0.7 2.681000e-08 0 2.700000e-08 0
+ 2.701000e-08 0.7 2.720000e-08 0.7 2.721000e-08 0 2.740000e-08 0 2.741000e-08 0.7 3.080000e-08 0.7
+ 3.081000e-08 0 3.100000e-08 0 3.101000e-08 0.7 3.120000e-08 0.7 3.121000e-08 0 3.140000e-08 0
+ 3.141000e-08 0.7 3.480000e-08 0.7 3.481000e-08 0 3.500000e-08 0 3.501000e-08 0.7 3.520000e-08 0.7
+ 3.521000e-08 0 3.540000e-08 0 3.541000e-08 0.7 3.620000e-08 0.7 3.621000e-08 0 3.920000e-08 0
+ 3.921000e-08 0.7 3.940000e-08 0.7 3.941000e-08 0 4.320000e-08 0 4.321000e-08 0.7 4.340000e-08 0.7
+ 4.341000e-08 0 4.720000e-08 0 4.721000e-08 0.7 4.740000e-08 0.7 4.741000e-08 0 5.120000e-08 0
+ 5.121000e-08 0.7 5.140000e-08 0.7 5.141000e-08 0 5.520000e-08 0 5.521000e-08 0.7 5.540000e-08 0.7
+ 5.541000e-08 0 5.920000e-08 0 5.921000e-08 0.7 5.940000e-08 0.7 5.941000e-08 0 6.020000e-08 0
+ 6.021000e-08 0.7 6.280000e-08 0.7 6.281000e-08 0 6.300000e-08 0 6.301000e-08 0.7 6.320000e-08 0.7
+ 6.321000e-08 0 6.340000e-08 0 6.341000e-08 0.7 6.680000e-08 0.7 6.681000e-08 0 6.700000e-08 0
+ 6.701000e-08 0.7 6.720000e-08 0.7 6.721000e-08 0 6.740000e-08 0 6.741000e-08 0.7 7.080000e-08 0.7
+ 7.081000e-08 0 7.100000e-08 0 7.101000e-08 0.7 7.120000e-08 0.7 7.121000e-08 0 7.140000e-08 0
+ 7.141000e-08 0.7 7.220000e-08 0.7 7.221000e-08 0 7.520000e-08 0 7.521000e-08 0.7 7.540000e-08 0.7
+ 7.541000e-08 0 7.920000e-08 0 7.921000e-08 0.7 7.940000e-08 0.7 7.941000e-08 0 8.320000e-08 0
+ 8.321000e-08 0.7 8.340000e-08 0.7 8.341000e-08 0 8.720000e-08 0 8.721000e-08 0.7 8.740000e-08 0.7
+ 8.741000e-08 0 9.120000e-08 0 9.121000e-08 0.7 9.140000e-08 0.7 9.141000e-08 0 9.520000e-08 0
+ 9.521000e-08 0.7 9.540000e-08 0.7 9.541000e-08 0 9.620000e-08 0 9.621000e-08 0.7 9.880000e-08 0.7
+ 9.881000e-08 0 9.900000e-08 0 9.901000e-08 0.7 9.920000e-08 0.7 9.921000e-08 0 9.940000e-08 0
+ 9.941000e-08 0.7 1.028000e-07 0.7 1.028100e-07 0 1.030000e-07 0 1.030100e-07 0.7 1.032000e-07 0.7
+ 1.032100e-07 0 1.034000e-07 0 1.034100e-07 0.7 1.068000e-07 0.7 1.068100e-07 0 1.070000e-07 0
+ 1.070100e-07 0.7 1.072000e-07 0.7 1.072100e-07 0 1.074000e-07 0 1.074100e-07 0.7 1.082000e-07 0.7
+ 1.082100e-07 0 1.112000e-07 0 1.112100e-07 0.7 1.114000e-07 0.7 1.114100e-07 0 1.152000e-07 0
+ 1.152100e-07 0.7 1.154000e-07 0.7 1.154100e-07 0 1.192000e-07 0 1.192100e-07 0.7 1.194000e-07 0.7
+ 1.194100e-07 0 1.232000e-07 0 1.232100e-07 0.7 1.234000e-07 0.7 1.234100e-07 0 1.272000e-07 0
+ 1.272100e-07 0.7 1.274000e-07 0.7 1.274100e-07 0 1.312000e-07 0 1.312100e-07 0.7 1.314000e-07 0.7
+ 1.314100e-07 0 1.322000e-07 0 1.322100e-07 0.7 1.348000e-07 0.7 1.348100e-07 0 1.350000e-07 0
+ 1.350100e-07 0.7 1.352000e-07 0.7 1.352100e-07 0 1.354000e-07 0 1.354100e-07 0.7 1.388000e-07 0.7
+ 1.388100e-07 0 1.390000e-07 0 1.390100e-07 0.7 1.392000e-07 0.7 1.392100e-07 0 1.394000e-07 0
+ 1.394100e-07 0.7 1.428000e-07 0.7 1.428100e-07 0 1.430000e-07 0 1.430100e-07 0.7 1.432000e-07 0.7
+ 1.432100e-07 0 1.434000e-07 0 1.434100e-07 0.7 1.442000e-07 0.7 1.442100e-07 0 1.472000e-07 0
+ 1.472100e-07 0.7 1.474000e-07 0.7 1.474100e-07 0 1.512000e-07 0 1.512100e-07 0.7 1.514000e-07 0.7
+ 1.514100e-07 0 1.552000e-07 0 1.552100e-07 0.7 1.554000e-07 0.7 1.554100e-07 0 1.592000e-07 0
+ 1.592100e-07 0.7 1.594000e-07 0.7 1.594100e-07 0 1.632000e-07 0 1.632100e-07 0.7 1.634000e-07 0.7
+ 1.634100e-07 0 1.672000e-07 0 1.672100e-07 0.7 1.674000e-07 0.7 1.674100e-07 0 1.682000e-07 0
+ 1.682100e-07 0.7 1.708000e-07 0.7 1.708100e-07 0 1.710000e-07 0 1.710100e-07 0.7 1.712000e-07 0.7
+ 1.712100e-07 0 1.714000e-07 0 1.714100e-07 0.7 1.748000e-07 0.7 1.748100e-07 0 1.750000e-07 0
+ 1.750100e-07 0.7 1.752000e-07 0.7 1.752100e-07 0 1.754000e-07 0 1.754100e-07 0.7 1.788000e-07 0.7
+ 1.788100e-07 0 1.790000e-07 0 1.790100e-07 0.7 1.792000e-07 0.7 1.792100e-07 0 1.794000e-07 0
+ 1.794100e-07 0.7 1.802000e-07 0.7 1.802100e-07 0 1.832000e-07 0 1.832100e-07 0.7 1.834000e-07 0.7
+ 1.834100e-07 0 1.872000e-07 0 1.872100e-07 0.7 1.874000e-07 0.7 1.874100e-07 0 1.912000e-07 0
+ 1.912100e-07 0.7 1.914000e-07 0.7 1.914100e-07 0 1.952000e-07 0 1.952100e-07 0.7 1.954000e-07 0.7
+ 1.954100e-07 0 1.992000e-07 0 1.992100e-07 0.7 1.994000e-07 0.7 1.994100e-07 0 2.032000e-07 0
+ 2.032100e-07 0.7 2.034000e-07 0.7 2.034100e-07 0 2.042000e-07 0 2.042100e-07 0.7 2.068000e-07 0.7
+ 2.068100e-07 0 2.070000e-07 0 2.070100e-07 0.7 2.072000e-07 0.7 2.072100e-07 0 2.074000e-07 0
+ 2.074100e-07 0.7 2.108000e-07 0.7 2.108100e-07 0 2.110000e-07 0 2.110100e-07 0.7 2.112000e-07 0.7
+ 2.112100e-07 0 2.114000e-07 0 2.114100e-07 0.7 2.148000e-07 0.7 2.148100e-07 0 2.150000e-07 0
+ 2.150100e-07 0.7 2.152000e-07 0.7 2.152100e-07 0 2.154000e-07 0 2.154100e-07 0.7 2.162000e-07 0.7
+ 2.162100e-07 0 2.192000e-07 0 2.192100e-07 0.7 2.194000e-07 0.7 2.194100e-07 0 2.232000e-07 0
+ 2.232100e-07 0.7 2.234000e-07 0.7 2.234100e-07 0 2.272000e-07 0 2.272100e-07 0.7 2.274000e-07 0.7
+ 2.274100e-07 0 2.312000e-07 0 2.312100e-07 0.7 2.314000e-07 0.7 2.314100e-07 0 2.352000e-07 0
+ 2.352100e-07 0.7 2.354000e-07 0.7 2.354100e-07 0 2.392000e-07 0 2.392100e-07 0.7 2.394000e-07 0.7
+ 2.394100e-07 0 2.402000e-07 0 2.402100e-07 0.7 2.428000e-07 0.7 2.428100e-07 0 2.430000e-07 0
+ 2.430100e-07 0.7 2.432000e-07 0.7 2.432100e-07 0 2.434000e-07 0 2.434100e-07 0.7 2.468000e-07 0.7
+ 2.468100e-07 0 2.470000e-07 0 2.470100e-07 0.7 2.472000e-07 0.7 2.472100e-07 0 2.474000e-07 0
+ 2.474100e-07 0.7 2.508000e-07 0.7 2.508100e-07 0 2.510000e-07 0 2.510100e-07 0.7 2.512000e-07 0.7
+ 2.512100e-07 0 2.514000e-07 0 2.514100e-07 0.7 2.522000e-07 0.7 2.522100e-07 0 2.552000e-07 0
+ 2.552100e-07 0.7 2.554000e-07 0.7 2.554100e-07 0 2.592000e-07 0 2.592100e-07 0.7 2.594000e-07 0.7
+ 2.594100e-07 0 2.632000e-07 0 2.632100e-07 0.7 2.634000e-07 0.7 2.634100e-07 0 2.672000e-07 0
+ 2.672100e-07 0.7 2.674000e-07 0.7 2.674100e-07 0 2.712000e-07 0 2.712100e-07 0.7 2.714000e-07 0.7
+ 2.714100e-07 0 2.752000e-07 0 2.752100e-07 0.7 2.754000e-07 0.7 2.754100e-07 0 2.762000e-07 0
+ 2.762100e-07 0.7 2.788000e-07 0.7 2.788100e-07 0 2.790000e-07 0 2.790100e-07 0.7 2.792000e-07 0.7
+ 2.792100e-07 0 2.794000e-07 0 2.794100e-07 0.7 2.828000e-07 0.7 2.828100e-07 0 2.830000e-07 0
+ 2.830100e-07 0.7 2.832000e-07 0.7 2.832100e-07 0 2.834000e-07 0 2.834100e-07 0.7 2.868000e-07 0.7
+ 2.868100e-07 0 2.870000e-07 0 2.870100e-07 0.7 2.872000e-07 0.7 2.872100e-07 0 2.874000e-07 0
+ 2.874100e-07 0.7 2.882000e-07 0.7 2.882100e-07 0 2.912000e-07 0 2.912100e-07 0.7 2.914000e-07 0.7
+ 2.914100e-07 0 2.952000e-07 0 2.952100e-07 0.7 2.954000e-07 0.7 2.954100e-07 0 2.992000e-07 0
+ 2.992100e-07 0.7 2.994000e-07 0.7 2.994100e-07 0 3.032000e-07 0 3.032100e-07 0.7 3.034000e-07 0.7
+ 3.034100e-07 0 3.072000e-07 0 3.072100e-07 0.7 3.074000e-07 0.7 3.074100e-07 0 3.112000e-07 0
+ 3.112100e-07 0.7 3.114000e-07 0.7 3.114100e-07 0 3.122000e-07 0 3.122100e-07 0.7 3.148000e-07 0.7
+ 3.148100e-07 0 3.150000e-07 0 3.150100e-07 0.7 3.152000e-07 0.7 3.152100e-07 0 3.154000e-07 0
+ 3.154100e-07 0.7 3.188000e-07 0.7 3.188100e-07 0 3.190000e-07 0 3.190100e-07 0.7 3.192000e-07 0.7
+ 3.192100e-07 0 3.194000e-07 0 3.194100e-07 0.7 3.228000e-07 0.7 3.228100e-07 0 3.230000e-07 0
+ 3.230100e-07 0.7 3.232000e-07 0.7 3.232100e-07 0 3.234000e-07 0 3.234100e-07 0.7 3.242000e-07 0.7
+ 3.242100e-07 0 3.272000e-07 0 3.272100e-07 0.7 3.274000e-07 0.7 3.274100e-07 0 3.312000e-07 0
+ 3.312100e-07 0.7 3.314000e-07 0.7 3.314100e-07 0 3.352000e-07 0 3.352100e-07 0.7 3.354000e-07 0.7
+ 3.354100e-07 0 3.392000e-07 0 3.392100e-07 0.7 3.394000e-07 0.7 3.394100e-07 0 3.432000e-07 0
+ 3.432100e-07 0.7 3.434000e-07 0.7 3.434100e-07 0 3.472000e-07 0 3.472100e-07 0.7 3.474000e-07 0.7
+ 3.474100e-07 0 3.482000e-07 0 3.482100e-07 0.7 3.508000e-07 0.7 3.508100e-07 0 3.510000e-07 0
+ 3.510100e-07 0.7 3.512000e-07 0.7 3.512100e-07 0 3.514000e-07 0 3.514100e-07 0.7 3.548000e-07 0.7
+ 3.548100e-07 0 3.550000e-07 0 3.550100e-07 0.7 3.552000e-07 0.7 3.552100e-07 0 3.554000e-07 0
+ 3.554100e-07 0.7 3.588000e-07 0.7 3.588100e-07 0 3.590000e-07 0 3.590100e-07 0.7 3.592000e-07 0.7
+ 3.592100e-07 0 3.594000e-07 0 3.594100e-07 0.7 3.602000e-07 0.7 3.602100e-07 0 3.632000e-07 0
+ 3.632100e-07 0.7 3.634000e-07 0.7 3.634100e-07 0 3.672000e-07 0 3.672100e-07 0.7 3.674000e-07 0.7
+ 3.674100e-07 0 3.712000e-07 0 3.712100e-07 0.7 3.714000e-07 0.7 3.714100e-07 0 3.752000e-07 0
+ 3.752100e-07 0.7 3.754000e-07 0.7 3.754100e-07 0 3.792000e-07 0 3.792100e-07 0.7 3.794000e-07 0.7
+ 3.794100e-07 0 3.832000e-07 0 3.832100e-07 0.7 3.834000e-07 0.7 3.834100e-07 0 3.842000e-07 0
+ 3.842100e-07 0.7 3.868000e-07 0.7 3.868100e-07 0 3.870000e-07 0 3.870100e-07 0.7 3.872000e-07 0.7
+ 3.872100e-07 0 3.874000e-07 0 3.874100e-07 0.7 3.908000e-07 0.7 3.908100e-07 0 3.910000e-07 0
+ 3.910100e-07 0.7 3.912000e-07 0.7 3.912100e-07 0 3.914000e-07 0 3.914100e-07 0.7 3.948000e-07 0.7
+ 3.948100e-07 0 3.950000e-07 0 3.950100e-07 0.7 3.952000e-07 0.7 3.952100e-07 0 3.954000e-07 0
+ 3.954100e-07 0.7 3.962000e-07 0.7 3.962100e-07 0 3.992000e-07 0 3.992100e-07 0.7 3.994000e-07 0.7
+ 3.994100e-07 0 4.032000e-07 0 4.032100e-07 0.7 4.034000e-07 0.7 4.034100e-07 0 4.072000e-07 0
+ 4.072100e-07 0.7 4.074000e-07 0.7 4.074100e-07 0 4.112000e-07 0 4.112100e-07 0.7 4.114000e-07 0.7
+ 4.114100e-07 0 4.152000e-07 0 4.152100e-07 0.7 4.154000e-07 0.7 4.154100e-07 0 4.192000e-07 0
+ 4.192100e-07 0.7 4.194000e-07 0.7 4.194100e-07 0 4.202000e-07 0 4.202100e-07 0.7 4.228000e-07 0.7
+ 4.228100e-07 0 4.230000e-07 0 4.230100e-07 0.7 4.232000e-07 0.7 4.232100e-07 0 4.234000e-07 0
+ 4.234100e-07 0.7 4.268000e-07 0.7 4.268100e-07 0 4.270000e-07 0 4.270100e-07 0.7 4.272000e-07 0.7
+ 4.272100e-07 0 4.274000e-07 0 4.274100e-07 0.7 4.308000e-07 0.7 4.308100e-07 0 4.310000e-07 0
+ 4.310100e-07 0.7 4.312000e-07 0.7 4.312100e-07 0 4.314000e-07 0 4.314100e-07 0.7 4.322000e-07 0.7
+ 4.322100e-07 0 4.352000e-07 0 4.352100e-07 0.7 4.354000e-07 0.7 4.354100e-07 0 4.392000e-07 0
+ 4.392100e-07 0.7 4.394000e-07 0.7 4.394100e-07 0 4.432000e-07 0 4.432100e-07 0.7 4.434000e-07 0.7
+ 4.434100e-07 0 4.472000e-07 0 4.472100e-07 0.7 4.474000e-07 0.7 4.474100e-07 0 4.512000e-07 0
+ 4.512100e-07 0.7 4.514000e-07 0.7 4.514100e-07 0 4.552000e-07 0 4.552100e-07 0.7 4.554000e-07 0.7
+ 4.554100e-07 0 4.562000e-07 0 4.562100e-07 0.7 4.588000e-07 0.7 4.588100e-07 0 4.590000e-07 0
+ 4.590100e-07 0.7 4.592000e-07 0.7 4.592100e-07 0 4.594000e-07 0 4.594100e-07 0.7 4.628000e-07 0.7
+ 4.628100e-07 0 4.630000e-07 0 4.630100e-07 0.7 4.632000e-07 0.7 4.632100e-07 0 4.634000e-07 0
+ 4.634100e-07 0.7 4.668000e-07 0.7 4.668100e-07 0 4.670000e-07 0 4.670100e-07 0.7 4.672000e-07 0.7
+ 4.672100e-07 0 4.674000e-07 0 4.674100e-07 0.7 4.682000e-07 0.7 4.682100e-07 0 4.712000e-07 0
+ 4.712100e-07 0.7 4.714000e-07 0.7 4.714100e-07 0 4.752000e-07 0 4.752100e-07 0.7 4.754000e-07 0.7
+ 4.754100e-07 0 4.792000e-07 0 4.792100e-07 0.7 4.794000e-07 0.7 4.794100e-07 0 4.832000e-07 0
+ 4.832100e-07 0.7 4.834000e-07 0.7 4.834100e-07 0 4.872000e-07 0 4.872100e-07 0.7 4.874000e-07 0.7
+ 4.874100e-07 0 4.912000e-07 0 4.912100e-07 0.7 4.914000e-07 0.7 4.914100e-07 0 4.922000e-07 0
+ 4.922100e-07 0.7 4.948000e-07 0.7 4.948100e-07 0 4.950000e-07 0 4.950100e-07 0.7 4.952000e-07 0.7
+ 4.952100e-07 0 4.954000e-07 0 4.954100e-07 0.7 4.988000e-07 0.7 4.988100e-07 0 4.990000e-07 0
+ 4.990100e-07 0.7 4.992000e-07 0.7 4.992100e-07 0 4.994000e-07 0 4.994100e-07 0.7 5.028000e-07 0.7
+ 5.028100e-07 0 5.030000e-07 0 5.030100e-07 0.7 5.032000e-07 0.7 5.032100e-07 0 5.034000e-07 0
+ 5.034100e-07 0.7 5.042000e-07 0.7 5.042100e-07 0 5.072000e-07 0 5.072100e-07 0.7 5.074000e-07 0.7
+ 5.074100e-07 0 5.112000e-07 0 5.112100e-07 0.7 5.114000e-07 0.7 5.114100e-07 0 5.152000e-07 0
+ 5.152100e-07 0.7 5.154000e-07 0.7 5.154100e-07 0 5.192000e-07 0 5.192100e-07 0.7 5.194000e-07 0.7
+ 5.194100e-07 0 5.232000e-07 0 5.232100e-07 0.7 5.234000e-07 0.7 5.234100e-07 0 5.272000e-07 0
+ 5.272100e-07 0.7 5.274000e-07 0.7 5.274100e-07 0 5.282000e-07 0 5.282100e-07 0.7 5.308000e-07 0.7
+ 5.308100e-07 0 5.310000e-07 0 5.310100e-07 0.7 5.312000e-07 0.7 5.312100e-07 0 5.314000e-07 0
+ 5.314100e-07 0.7 5.348000e-07 0.7 5.348100e-07 0 5.350000e-07 0 5.350100e-07 0.7 5.352000e-07 0.7
+ 5.352100e-07 0 5.354000e-07 0 5.354100e-07 0.7 5.388000e-07 0.7 5.388100e-07 0 5.390000e-07 0
+ 5.390100e-07 0.7 5.392000e-07 0.7 5.392100e-07 0 5.394000e-07 0 5.394100e-07 0.7 5.402000e-07 0.7
+ 5.402100e-07 0 5.432000e-07 0 5.432100e-07 0.7 5.434000e-07 0.7 5.434100e-07 0 5.472000e-07 0
+ 5.472100e-07 0.7 5.474000e-07 0.7 5.474100e-07 0 5.512000e-07 0 5.512100e-07 0.7 5.514000e-07 0.7
+ 5.514100e-07 0 5.552000e-07 0 5.552100e-07 0.7 5.554000e-07 0.7 5.554100e-07 0 5.592000e-07 0
+ 5.592100e-07 0.7 5.594000e-07 0.7 5.594100e-07 0 5.632000e-07 0 5.632100e-07 0.7 5.634000e-07 0.7
+ 5.634100e-07 0 5.642000e-07 0 5.642100e-07 0.7 5.668000e-07 0.7 5.668100e-07 0 5.670000e-07 0
+ 5.670100e-07 0.7 5.672000e-07 0.7 5.672100e-07 0 5.674000e-07 0 5.674100e-07 0.7 5.708000e-07 0.7
+ 5.708100e-07 0 5.710000e-07 0 5.710100e-07 0.7 5.712000e-07 0.7 5.712100e-07 0 5.714000e-07 0
+ 5.714100e-07 0.7 5.748000e-07 0.7 5.748100e-07 0 5.750000e-07 0 5.750100e-07 0.7 5.752000e-07 0.7
+ 5.752100e-07 0 5.754000e-07 0 5.754100e-07 0.7 5.762000e-07 0.7 5.762100e-07 0 5.792000e-07 0
+ 5.792100e-07 0.7 5.794000e-07 0.7 5.794100e-07 0 5.832000e-07 0 5.832100e-07 0.7 5.834000e-07 0.7
+ 5.834100e-07 0 5.872000e-07 0 5.872100e-07 0.7 5.874000e-07 0.7 5.874100e-07 0 5.912000e-07 0
+ 5.912100e-07 0.7 5.914000e-07 0.7 5.914100e-07 0 5.952000e-07 0 5.952100e-07 0.7 5.954000e-07 0.7
+ 5.954100e-07 0 5.992000e-07 0 5.992100e-07 0.7 5.994000e-07 0.7 5.994100e-07 0 6.002000e-07 0
+ 6.002100e-07 0.7 6.028000e-07 0.7 6.028100e-07 0 6.030000e-07 0 6.030100e-07 0.7 6.032000e-07 0.7
+ 6.032100e-07 0 6.034000e-07 0 6.034100e-07 0.7 6.068000e-07 0.7 6.068100e-07 0 6.070000e-07 0
+ 6.070100e-07 0.7 6.072000e-07 0.7 6.072100e-07 0 6.074000e-07 0 6.074100e-07 0.7 6.108000e-07 0.7
+ 6.108100e-07 0 6.110000e-07 0 6.110100e-07 0.7 6.112000e-07 0.7 6.112100e-07 0 6.114000e-07 0
+ 6.114100e-07 0.7 6.122000e-07 0.7 6.122100e-07 0 6.152000e-07 0 6.152100e-07 0.7 6.154000e-07 0.7
+ 6.154100e-07 0 6.192000e-07 0 6.192100e-07 0.7 6.194000e-07 0.7 6.194100e-07 0 6.232000e-07 0
+ 6.232100e-07 0.7 6.234000e-07 0.7 6.234100e-07 0 6.272000e-07 0 6.272100e-07 0.7 6.274000e-07 0.7
+ 6.274100e-07 0 6.312000e-07 0 6.312100e-07 0.7 6.314000e-07 0.7 6.314100e-07 0 6.352000e-07 0
+ 6.352100e-07 0.7 6.354000e-07 0.7 6.354100e-07 0 6.362000e-07 0 6.362100e-07 0.7 6.388000e-07 0.7
+ 6.388100e-07 0 6.390000e-07 0 6.390100e-07 0.7 6.392000e-07 0.7 6.392100e-07 0 6.394000e-07 0
+ 6.394100e-07 0.7 6.428000e-07 0.7 6.428100e-07 0 6.430000e-07 0 6.430100e-07 0.7 6.432000e-07 0.7
+ 6.432100e-07 0 6.434000e-07 0 6.434100e-07 0.7 6.468000e-07 0.7 6.468100e-07 0 6.470000e-07 0
+ 6.470100e-07 0.7 6.472000e-07 0.7 6.472100e-07 0 6.474000e-07 0 6.474100e-07 0.7 6.482000e-07 0.7
+ 6.482100e-07 0 6.512000e-07 0 6.512100e-07 0.7 6.514000e-07 0.7 6.514100e-07 0 6.552000e-07 0
+ 6.552100e-07 0.7 6.554000e-07 0.7 6.554100e-07 0 6.592000e-07 0 6.592100e-07 0.7 6.594000e-07 0.7
+ 6.594100e-07 0 6.632000e-07 0 6.632100e-07 0.7 6.634000e-07 0.7 6.634100e-07 0 6.672000e-07 0
+ 6.672100e-07 0.7 6.674000e-07 0.7 6.674100e-07 0 6.712000e-07 0 6.712100e-07 0.7 6.714000e-07 0.7
+ 6.714100e-07 0 6.722000e-07 0 6.722100e-07 0.7 6.748000e-07 0.7 6.748100e-07 0 6.750000e-07 0
+ 6.750100e-07 0.7 6.752000e-07 0.7 6.752100e-07 0 6.754000e-07 0 6.754100e-07 0.7 6.788000e-07 0.7
+ 6.788100e-07 0 6.790000e-07 0 6.790100e-07 0.7 6.792000e-07 0.7 6.792100e-07 0 6.794000e-07 0
+ 6.794100e-07 0.7 6.828000e-07 0.7 6.828100e-07 0 6.830000e-07 0 6.830100e-07 0.7 6.832000e-07 0.7
+ 6.832100e-07 0 6.834000e-07 0 6.834100e-07 0.7 6.842000e-07 0.7 6.842100e-07 0 6.872000e-07 0
+ 6.872100e-07 0.7 6.874000e-07 0.7 6.874100e-07 0 6.912000e-07 0 6.912100e-07 0.7 6.914000e-07 0.7
+ 6.914100e-07 0 6.952000e-07 0 6.952100e-07 0.7 6.954000e-07 0.7 6.954100e-07 0 6.992000e-07 0
+ 6.992100e-07 0.7 6.994000e-07 0.7 6.994100e-07 0 7.032000e-07 0 7.032100e-07 0.7 7.034000e-07 0.7
+ 7.034100e-07 0 7.072000e-07 0 7.072100e-07 0.7 7.074000e-07 0.7 7.074100e-07 0 7.082000e-07 0
+ 7.082100e-07 0.7 7.108000e-07 0.7 7.108100e-07 0 7.110000e-07 0 7.110100e-07 0.7 7.112000e-07 0.7
+ 7.112100e-07 0 7.114000e-07 0 7.114100e-07 0.7 7.148000e-07 0.7 7.148100e-07 0 7.150000e-07 0
+ 7.150100e-07 0.7 7.152000e-07 0.7 7.152100e-07 0 7.154000e-07 0 7.154100e-07 0.7 7.188000e-07 0.7
+ 7.188100e-07 0 7.190000e-07 0 7.190100e-07 0.7 7.192000e-07 0.7 7.192100e-07 0 7.194000e-07 0
+ 7.194100e-07 0.7 7.202000e-07 0.7 7.202100e-07 0 7.232000e-07 0 7.232100e-07 0.7 7.234000e-07 0.7
+ 7.234100e-07 0 7.272000e-07 0 7.272100e-07 0.7 7.274000e-07 0.7 7.274100e-07 0 7.312000e-07 0
+ 7.312100e-07 0.7 7.314000e-07 0.7 7.314100e-07 0 7.352000e-07 0 7.352100e-07 0.7 7.354000e-07 0.7
+ 7.354100e-07 0 7.392000e-07 0 7.392100e-07 0.7 7.394000e-07 0.7 7.394100e-07 0 7.432000e-07 0
+ 7.432100e-07 0.7 7.434000e-07 0.7 7.434100e-07 0 7.442000e-07 0 7.442100e-07 0.7 7.468000e-07 0.7
+ 7.468100e-07 0 7.470000e-07 0 7.470100e-07 0.7 7.472000e-07 0.7 7.472100e-07 0 7.474000e-07 0
+ 7.474100e-07 0.7 7.508000e-07 0.7 7.508100e-07 0 7.510000e-07 0 7.510100e-07 0.7 7.512000e-07 0.7
+ 7.512100e-07 0 7.514000e-07 0 7.514100e-07 0.7 7.548000e-07 0.7 7.548100e-07 0 7.550000e-07 0
+ 7.550100e-07 0.7 7.552000e-07 0.7 7.552100e-07 0 7.554000e-07 0 7.554100e-07 0.7 7.562000e-07 0.7
+ 7.562100e-07 0 7.592000e-07 0 7.592100e-07 0.7 7.594000e-07 0.7 7.594100e-07 0 7.632000e-07 0
+ 7.632100e-07 0.7 7.634000e-07 0.7 7.634100e-07 0 7.672000e-07 0 7.672100e-07 0.7 7.674000e-07 0.7
+ 7.674100e-07 0 7.712000e-07 0 7.712100e-07 0.7 7.714000e-07 0.7 7.714100e-07 0 7.752000e-07 0
+ 7.752100e-07 0.7 7.754000e-07 0.7 7.754100e-07 0 7.792000e-07 0 7.792100e-07 0.7 7.794000e-07 0.7
+ 7.794100e-07 0 7.802000e-07 0 7.802100e-07 0.7 7.828000e-07 0.7 7.828100e-07 0 7.830000e-07 0
+ 7.830100e-07 0.7 7.832000e-07 0.7 7.832100e-07 0 7.834000e-07 0 7.834100e-07 0.7 7.868000e-07 0.7
+ 7.868100e-07 0 7.870000e-07 0 7.870100e-07 0.7 7.872000e-07 0.7 7.872100e-07 0 7.874000e-07 0
+ 7.874100e-07 0.7 7.908000e-07 0.7 7.908100e-07 0 7.910000e-07 0 7.910100e-07 0.7 7.912000e-07 0.7
+ 7.912100e-07 0 7.914000e-07 0 7.914100e-07 0.7 7.922000e-07 0.7 7.922100e-07 0 7.952000e-07 0
+ 7.952100e-07 0.7 7.954000e-07 0.7 7.954100e-07 0 7.992000e-07 0 7.992100e-07 0.7 7.994000e-07 0.7
+ 7.994100e-07 0 8.032000e-07 0 8.032100e-07 0.7 8.034000e-07 0.7 8.034100e-07 0 8.072000e-07 0
+ 8.072100e-07 0.7 8.074000e-07 0.7 8.074100e-07 0 8.112000e-07 0 8.112100e-07 0.7 8.114000e-07 0.7
+ 8.114100e-07 0 8.152000e-07 0 8.152100e-07 0.7 8.154000e-07 0.7 8.154100e-07 0 8.162000e-07 0
+ 8.162100e-07 0.7 8.188000e-07 0.7 8.188100e-07 0 8.190000e-07 0 8.190100e-07 0.7 8.192000e-07 0.7
+ 8.192100e-07 0 8.194000e-07 0 8.194100e-07 0.7 8.228000e-07 0.7 8.228100e-07 0 8.230000e-07 0
+ 8.230100e-07 0.7 8.232000e-07 0.7 8.232100e-07 0 8.234000e-07 0 8.234100e-07 0.7 8.268000e-07 0.7
+ 8.268100e-07 0 8.270000e-07 0 8.270100e-07 0.7 8.272000e-07 0.7 8.272100e-07 0 8.274000e-07 0
+ 8.274100e-07 0.7 8.282000e-07 0.7 8.282100e-07 0 8.312000e-07 0 8.312100e-07 0.7 8.314000e-07 0.7
+ 8.314100e-07 0 8.352000e-07 0 8.352100e-07 0.7 8.354000e-07 0.7 8.354100e-07 0 8.392000e-07 0
+ 8.392100e-07 0.7 8.394000e-07 0.7 8.394100e-07 0 8.432000e-07 0 8.432100e-07 0.7 8.434000e-07 0.7
+ 8.434100e-07 0 8.472000e-07 0 8.472100e-07 0.7 8.474000e-07 0.7 8.474100e-07 0 8.512000e-07 0
+ 8.512100e-07 0.7 8.514000e-07 0.7 8.514100e-07 0 8.522000e-07 0 8.522100e-07 0.7 8.548000e-07 0.7
+ 8.548100e-07 0 8.550000e-07 0 8.550100e-07 0.7 8.552000e-07 0.7 8.552100e-07 0 8.554000e-07 0
+ 8.554100e-07 0.7 8.588000e-07 0.7 8.588100e-07 0 8.590000e-07 0 8.590100e-07 0.7 8.592000e-07 0.7
+ 8.592100e-07 0 8.594000e-07 0 8.594100e-07 0.7 8.628000e-07 0.7 8.628100e-07 0 8.630000e-07 0
+ 8.630100e-07 0.7 8.632000e-07 0.7 8.632100e-07 0 8.634000e-07 0 8.634100e-07 0.7 8.642000e-07 0.7
+ 8.642100e-07 0 8.672000e-07 0 8.672100e-07 0.7 8.674000e-07 0.7 8.674100e-07 0 8.712000e-07 0
+ 8.712100e-07 0.7 8.714000e-07 0.7 8.714100e-07 0 8.752000e-07 0 8.752100e-07 0.7 8.754000e-07 0.7
+ 8.754100e-07 0 8.792000e-07 0 8.792100e-07 0.7 8.794000e-07 0.7 8.794100e-07 0 8.832000e-07 0
+ 8.832100e-07 0.7 8.834000e-07 0.7 8.834100e-07 0 8.872000e-07 0 8.872100e-07 0.7 8.874000e-07 0.7
+ 8.874100e-07 0 8.882000e-07 0 8.882100e-07 0.7 8.908000e-07 0.7 8.908100e-07 0 8.910000e-07 0
+ 8.910100e-07 0.7 8.912000e-07 0.7 8.912100e-07 0 8.914000e-07 0 8.914100e-07 0.7 8.948000e-07 0.7
+ 8.948100e-07 0 8.950000e-07 0 8.950100e-07 0.7 8.952000e-07 0.7 8.952100e-07 0 8.954000e-07 0
+ 8.954100e-07 0.7 8.988000e-07 0.7 8.988100e-07 0 8.990000e-07 0 8.990100e-07 0.7 8.992000e-07 0.7
+ 8.992100e-07 0 8.994000e-07 0 8.994100e-07 0.7 9.002000e-07 0.7 9.002100e-07 0 9.032000e-07 0
+ 9.032100e-07 0.7 9.034000e-07 0.7 9.034100e-07 0 9.072000e-07 0 9.072100e-07 0.7 9.074000e-07 0.7
+ 9.074100e-07 0 9.112000e-07 0 9.112100e-07 0.7 9.114000e-07 0.7 9.114100e-07 0 9.152000e-07 0
+ 9.152100e-07 0.7 9.154000e-07 0.7 9.154100e-07 0 9.192000e-07 0 9.192100e-07 0.7 9.194000e-07 0.7
+ 9.194100e-07 0 9.232000e-07 0 9.232100e-07 0.7 9.234000e-07 0.7 9.234100e-07 0 9.242000e-07 0
+ 9.242100e-07 0.7 9.268000e-07 0.7 9.268100e-07 0 9.270000e-07 0 9.270100e-07 0.7 9.272000e-07 0.7
+ 9.272100e-07 0 9.274000e-07 0 9.274100e-07 0.7 9.308000e-07 0.7 9.308100e-07 0 9.310000e-07 0
+ 9.310100e-07 0.7 9.312000e-07 0.7 9.312100e-07 0 9.314000e-07 0 9.314100e-07 0.7 9.348000e-07 0.7
+ 9.348100e-07 0 9.350000e-07 0 9.350100e-07 0.7 9.352000e-07 0.7 9.352100e-07 0 9.354000e-07 0
+ 9.354100e-07 0.7 9.362000e-07 0.7 9.362100e-07 0 9.392000e-07 0 9.392100e-07 0.7 9.394000e-07 0.7
+ 9.394100e-07 0 9.432000e-07 0 9.432100e-07 0.7 9.434000e-07 0.7 9.434100e-07 0 9.472000e-07 0
+ 9.472100e-07 0.7 9.474000e-07 0.7 9.474100e-07 0 9.512000e-07 0 9.512100e-07 0.7 9.514000e-07 0.7
+ 9.514100e-07 0 9.552000e-07 0 9.552100e-07 0.7 9.554000e-07 0.7 9.554100e-07 0 9.592000e-07 0
+ 9.592100e-07 0.7 9.594000e-07 0.7 9.594100e-07 0 9.602000e-07 0 9.602100e-07 0.7 9.628000e-07 0.7
+ 9.628100e-07 0 9.630000e-07 0 9.630100e-07 0.7 9.632000e-07 0.7 9.632100e-07 0 9.634000e-07 0
+ 9.634100e-07 0.7 9.668000e-07 0.7 9.668100e-07 0 9.670000e-07 0 9.670100e-07 0.7 9.672000e-07 0.7
+ 9.672100e-07 0 9.674000e-07 0 9.674100e-07 0.7 9.708000e-07 0.7 9.708100e-07 0 9.710000e-07 0
+ 9.710100e-07 0.7 9.712000e-07 0.7 9.712100e-07 0 9.714000e-07 0 9.714100e-07 0.7 )
v_XB0 src_XB0 0 pwl(
+ 0.000000e+00 0 3.600000e-09 0 3.610000e-09 0.7 3.800000e-09 0.7 3.810000e-09 0 4.000000e-09 0
+ 4.010000e-09 0.7 7.600000e-09 0.7 7.610000e-09 0 7.800000e-09 0 7.810000e-09 0.7 1.160000e-08 0.7
+ 1.161000e-08 0 1.180000e-08 0 1.181000e-08 0.7 1.220000e-08 0.7 1.221000e-08 0 1.560000e-08 0
+ 1.561000e-08 0.7 1.580000e-08 0.7 1.581000e-08 0 1.600000e-08 0 1.601000e-08 0.7 1.960000e-08 0.7
+ 1.961000e-08 0 1.980000e-08 0 1.981000e-08 0.7 2.360000e-08 0.7 2.361000e-08 0 2.380000e-08 0
+ 2.381000e-08 0.7 2.420000e-08 0.7 2.421000e-08 0 2.760000e-08 0 2.761000e-08 0.7 2.780000e-08 0.7
+ 2.781000e-08 0 2.800000e-08 0 2.801000e-08 0.7 3.160000e-08 0.7 3.161000e-08 0 3.180000e-08 0
+ 3.181000e-08 0.7 3.560000e-08 0.7 3.561000e-08 0 3.580000e-08 0 3.581000e-08 0.7 3.620000e-08 0.7
+ 3.621000e-08 0 3.960000e-08 0 3.961000e-08 0.7 3.980000e-08 0.7 3.981000e-08 0 4.000000e-08 0
+ 4.001000e-08 0.7 4.360000e-08 0.7 4.361000e-08 0 4.380000e-08 0 4.381000e-08 0.7 4.760000e-08 0.7
+ 4.761000e-08 0 4.780000e-08 0 4.781000e-08 0.7 4.820000e-08 0.7 4.821000e-08 0 5.160000e-08 0
+ 5.161000e-08 0.7 5.180000e-08 0.7 5.181000e-08 0 5.200000e-08 0 5.201000e-08 0.7 5.560000e-08 0.7
+ 5.561000e-08 0 5.580000e-08 0 5.581000e-08 0.7 5.960000e-08 0.7 5.961000e-08 0 5.980000e-08 0
+ 5.981000e-08 0.7 6.020000e-08 0.7 6.021000e-08 0 6.360000e-08 0 6.361000e-08 0.7 6.380000e-08 0.7
+ 6.381000e-08 0 6.400000e-08 0 6.401000e-08 0.7 6.760000e-08 0.7 6.761000e-08 0 6.780000e-08 0
+ 6.781000e-08 0.7 7.160000e-08 0.7 7.161000e-08 0 7.180000e-08 0 7.181000e-08 0.7 7.220000e-08 0.7
+ 7.221000e-08 0 7.560000e-08 0 7.561000e-08 0.7 7.580000e-08 0.7 7.581000e-08 0 7.600000e-08 0
+ 7.601000e-08 0.7 7.960000e-08 0.7 7.961000e-08 0 7.980000e-08 0 7.981000e-08 0.7 8.360000e-08 0.7
+ 8.361000e-08 0 8.380000e-08 0 8.381000e-08 0.7 8.420000e-08 0.7 8.421000e-08 0 8.760000e-08 0
+ 8.761000e-08 0.7 8.780000e-08 0.7 8.781000e-08 0 8.800000e-08 0 8.801000e-08 0.7 9.160000e-08 0.7
+ 9.161000e-08 0 9.180000e-08 0 9.181000e-08 0.7 9.560000e-08 0.7 9.561000e-08 0 9.580000e-08 0
+ 9.581000e-08 0.7 9.620000e-08 0.7 9.621000e-08 0 9.960000e-08 0 9.961000e-08 0.7 9.980000e-08 0.7
+ 9.981000e-08 0 1.000000e-07 0 1.000100e-07 0.7 1.036000e-07 0.7 1.036100e-07 0 1.038000e-07 0
+ 1.038100e-07 0.7 1.076000e-07 0.7 1.076100e-07 0 1.078000e-07 0 1.078100e-07 0.7 1.082000e-07 0.7
+ 1.082100e-07 0 1.116000e-07 0 1.116100e-07 0.7 1.118000e-07 0.7 1.118100e-07 0 1.120000e-07 0
+ 1.120100e-07 0.7 1.156000e-07 0.7 1.156100e-07 0 1.158000e-07 0 1.158100e-07 0.7 1.196000e-07 0.7
+ 1.196100e-07 0 1.198000e-07 0 1.198100e-07 0.7 1.202000e-07 0.7 1.202100e-07 0 1.236000e-07 0
+ 1.236100e-07 0.7 1.238000e-07 0.7 1.238100e-07 0 1.240000e-07 0 1.240100e-07 0.7 1.276000e-07 0.7
+ 1.276100e-07 0 1.278000e-07 0 1.278100e-07 0.7 1.316000e-07 0.7 1.316100e-07 0 1.318000e-07 0
+ 1.318100e-07 0.7 1.322000e-07 0.7 1.322100e-07 0 1.356000e-07 0 1.356100e-07 0.7 1.358000e-07 0.7
+ 1.358100e-07 0 1.360000e-07 0 1.360100e-07 0.7 1.396000e-07 0.7 1.396100e-07 0 1.398000e-07 0
+ 1.398100e-07 0.7 1.436000e-07 0.7 1.436100e-07 0 1.438000e-07 0 1.438100e-07 0.7 1.442000e-07 0.7
+ 1.442100e-07 0 1.476000e-07 0 1.476100e-07 0.7 1.478000e-07 0.7 1.478100e-07 0 1.480000e-07 0
+ 1.480100e-07 0.7 1.516000e-07 0.7 1.516100e-07 0 1.518000e-07 0 1.518100e-07 0.7 1.556000e-07 0.7
+ 1.556100e-07 0 1.558000e-07 0 1.558100e-07 0.7 1.562000e-07 0.7 1.562100e-07 0 1.596000e-07 0
+ 1.596100e-07 0.7 1.598000e-07 0.7 1.598100e-07 0 1.600000e-07 0 1.600100e-07 0.7 1.636000e-07 0.7
+ 1.636100e-07 0 1.638000e-07 0 1.638100e-07 0.7 1.676000e-07 0.7 1.676100e-07 0 1.678000e-07 0
+ 1.678100e-07 0.7 1.682000e-07 0.7 1.682100e-07 0 1.716000e-07 0 1.716100e-07 0.7 1.718000e-07 0.7
+ 1.718100e-07 0 1.720000e-07 0 1.720100e-07 0.7 1.756000e-07 0.7 1.756100e-07 0 1.758000e-07 0
+ 1.758100e-07 0.7 1.796000e-07 0.7 1.796100e-07 0 1.798000e-07 0 1.798100e-07 0.7 1.802000e-07 0.7
+ 1.802100e-07 0 1.836000e-07 0 1.836100e-07 0.7 1.838000e-07 0.7 1.838100e-07 0 1.840000e-07 0
+ 1.840100e-07 0.7 1.876000e-07 0.7 1.876100e-07 0 1.878000e-07 0 1.878100e-07 0.7 1.916000e-07 0.7
+ 1.916100e-07 0 1.918000e-07 0 1.918100e-07 0.7 1.922000e-07 0.7 1.922100e-07 0 1.956000e-07 0
+ 1.956100e-07 0.7 1.958000e-07 0.7 1.958100e-07 0 1.960000e-07 0 1.960100e-07 0.7 1.996000e-07 0.7
+ 1.996100e-07 0 1.998000e-07 0 1.998100e-07 0.7 2.036000e-07 0.7 2.036100e-07 0 2.038000e-07 0
+ 2.038100e-07 0.7 2.042000e-07 0.7 2.042100e-07 0 2.076000e-07 0 2.076100e-07 0.7 2.078000e-07 0.7
+ 2.078100e-07 0 2.080000e-07 0 2.080100e-07 0.7 2.116000e-07 0.7 2.116100e-07 0 2.118000e-07 0
+ 2.118100e-07 0.7 2.156000e-07 0.7 2.156100e-07 0 2.158000e-07 0 2.158100e-07 0.7 2.162000e-07 0.7
+ 2.162100e-07 0 2.196000e-07 0 2.196100e-07 0.7 2.198000e-07 0.7 2.198100e-07 0 2.200000e-07 0
+ 2.200100e-07 0.7 2.236000e-07 0.7 2.236100e-07 0 2.238000e-07 0 2.238100e-07 0.7 2.276000e-07 0.7
+ 2.276100e-07 0 2.278000e-07 0 2.278100e-07 0.7 2.282000e-07 0.7 2.282100e-07 0 2.316000e-07 0
+ 2.316100e-07 0.7 2.318000e-07 0.7 2.318100e-07 0 2.320000e-07 0 2.320100e-07 0.7 2.356000e-07 0.7
+ 2.356100e-07 0 2.358000e-07 0 2.358100e-07 0.7 2.396000e-07 0.7 2.396100e-07 0 2.398000e-07 0
+ 2.398100e-07 0.7 2.402000e-07 0.7 2.402100e-07 0 2.436000e-07 0 2.436100e-07 0.7 2.438000e-07 0.7
+ 2.438100e-07 0 2.440000e-07 0 2.440100e-07 0.7 2.476000e-07 0.7 2.476100e-07 0 2.478000e-07 0
+ 2.478100e-07 0.7 2.516000e-07 0.7 2.516100e-07 0 2.518000e-07 0 2.518100e-07 0.7 2.522000e-07 0.7
+ 2.522100e-07 0 2.556000e-07 0 2.556100e-07 0.7 2.558000e-07 0.7 2.558100e-07 0 2.560000e-07 0
+ 2.560100e-07 0.7 2.596000e-07 0.7 2.596100e-07 0 2.598000e-07 0 2.598100e-07 0.7 2.636000e-07 0.7
+ 2.636100e-07 0 2.638000e-07 0 2.638100e-07 0.7 2.642000e-07 0.7 2.642100e-07 0 2.676000e-07 0
+ 2.676100e-07 0.7 2.678000e-07 0.7 2.678100e-07 0 2.680000e-07 0 2.680100e-07 0.7 2.716000e-07 0.7
+ 2.716100e-07 0 2.718000e-07 0 2.718100e-07 0.7 2.756000e-07 0.7 2.756100e-07 0 2.758000e-07 0
+ 2.758100e-07 0.7 2.762000e-07 0.7 2.762100e-07 0 2.796000e-07 0 2.796100e-07 0.7 2.798000e-07 0.7
+ 2.798100e-07 0 2.800000e-07 0 2.800100e-07 0.7 2.836000e-07 0.7 2.836100e-07 0 2.838000e-07 0
+ 2.838100e-07 0.7 2.876000e-07 0.7 2.876100e-07 0 2.878000e-07 0 2.878100e-07 0.7 2.882000e-07 0.7
+ 2.882100e-07 0 2.916000e-07 0 2.916100e-07 0.7 2.918000e-07 0.7 2.918100e-07 0 2.920000e-07 0
+ 2.920100e-07 0.7 2.956000e-07 0.7 2.956100e-07 0 2.958000e-07 0 2.958100e-07 0.7 2.996000e-07 0.7
+ 2.996100e-07 0 2.998000e-07 0 2.998100e-07 0.7 3.002000e-07 0.7 3.002100e-07 0 3.036000e-07 0
+ 3.036100e-07 0.7 3.038000e-07 0.7 3.038100e-07 0 3.040000e-07 0 3.040100e-07 0.7 3.076000e-07 0.7
+ 3.076100e-07 0 3.078000e-07 0 3.078100e-07 0.7 3.116000e-07 0.7 3.116100e-07 0 3.118000e-07 0
+ 3.118100e-07 0.7 3.122000e-07 0.7 3.122100e-07 0 3.156000e-07 0 3.156100e-07 0.7 3.158000e-07 0.7
+ 3.158100e-07 0 3.160000e-07 0 3.160100e-07 0.7 3.196000e-07 0.7 3.196100e-07 0 3.198000e-07 0
+ 3.198100e-07 0.7 3.236000e-07 0.7 3.236100e-07 0 3.238000e-07 0 3.238100e-07 0.7 3.242000e-07 0.7
+ 3.242100e-07 0 3.276000e-07 0 3.276100e-07 0.7 3.278000e-07 0.7 3.278100e-07 0 3.280000e-07 0
+ 3.280100e-07 0.7 3.316000e-07 0.7 3.316100e-07 0 3.318000e-07 0 3.318100e-07 0.7 3.356000e-07 0.7
+ 3.356100e-07 0 3.358000e-07 0 3.358100e-07 0.7 3.362000e-07 0.7 3.362100e-07 0 3.396000e-07 0
+ 3.396100e-07 0.7 3.398000e-07 0.7 3.398100e-07 0 3.400000e-07 0 3.400100e-07 0.7 3.436000e-07 0.7
+ 3.436100e-07 0 3.438000e-07 0 3.438100e-07 0.7 3.476000e-07 0.7 3.476100e-07 0 3.478000e-07 0
+ 3.478100e-07 0.7 3.482000e-07 0.7 3.482100e-07 0 3.516000e-07 0 3.516100e-07 0.7 3.518000e-07 0.7
+ 3.518100e-07 0 3.520000e-07 0 3.520100e-07 0.7 3.556000e-07 0.7 3.556100e-07 0 3.558000e-07 0
+ 3.558100e-07 0.7 3.596000e-07 0.7 3.596100e-07 0 3.598000e-07 0 3.598100e-07 0.7 3.602000e-07 0.7
+ 3.602100e-07 0 3.636000e-07 0 3.636100e-07 0.7 3.638000e-07 0.7 3.638100e-07 0 3.640000e-07 0
+ 3.640100e-07 0.7 3.676000e-07 0.7 3.676100e-07 0 3.678000e-07 0 3.678100e-07 0.7 3.716000e-07 0.7
+ 3.716100e-07 0 3.718000e-07 0 3.718100e-07 0.7 3.722000e-07 0.7 3.722100e-07 0 3.756000e-07 0
+ 3.756100e-07 0.7 3.758000e-07 0.7 3.758100e-07 0 3.760000e-07 0 3.760100e-07 0.7 3.796000e-07 0.7
+ 3.796100e-07 0 3.798000e-07 0 3.798100e-07 0.7 3.836000e-07 0.7 3.836100e-07 0 3.838000e-07 0
+ 3.838100e-07 0.7 3.842000e-07 0.7 3.842100e-07 0 3.876000e-07 0 3.876100e-07 0.7 3.878000e-07 0.7
+ 3.878100e-07 0 3.880000e-07 0 3.880100e-07 0.7 3.916000e-07 0.7 3.916100e-07 0 3.918000e-07 0
+ 3.918100e-07 0.7 3.956000e-07 0.7 3.956100e-07 0 3.958000e-07 0 3.958100e-07 0.7 3.962000e-07 0.7
+ 3.962100e-07 0 3.996000e-07 0 3.996100e-07 0.7 3.998000e-07 0.7 3.998100e-07 0 4.000000e-07 0
+ 4.000100e-07 0.7 4.036000e-07 0.7 4.036100e-07 0 4.038000e-07 0 4.038100e-07 0.7 4.076000e-07 0.7
+ 4.076100e-07 0 4.078000e-07 0 4.078100e-07 0.7 4.082000e-07 0.7 4.082100e-07 0 4.116000e-07 0
+ 4.116100e-07 0.7 4.118000e-07 0.7 4.118100e-07 0 4.120000e-07 0 4.120100e-07 0.7 4.156000e-07 0.7
+ 4.156100e-07 0 4.158000e-07 0 4.158100e-07 0.7 4.196000e-07 0.7 4.196100e-07 0 4.198000e-07 0
+ 4.198100e-07 0.7 4.202000e-07 0.7 4.202100e-07 0 4.236000e-07 0 4.236100e-07 0.7 4.238000e-07 0.7
+ 4.238100e-07 0 4.240000e-07 0 4.240100e-07 0.7 4.276000e-07 0.7 4.276100e-07 0 4.278000e-07 0
+ 4.278100e-07 0.7 4.316000e-07 0.7 4.316100e-07 0 4.318000e-07 0 4.318100e-07 0.7 4.322000e-07 0.7
+ 4.322100e-07 0 4.356000e-07 0 4.356100e-07 0.7 4.358000e-07 0.7 4.358100e-07 0 4.360000e-07 0
+ 4.360100e-07 0.7 4.396000e-07 0.7 4.396100e-07 0 4.398000e-07 0 4.398100e-07 0.7 4.436000e-07 0.7
+ 4.436100e-07 0 4.438000e-07 0 4.438100e-07 0.7 4.442000e-07 0.7 4.442100e-07 0 4.476000e-07 0
+ 4.476100e-07 0.7 4.478000e-07 0.7 4.478100e-07 0 4.480000e-07 0 4.480100e-07 0.7 4.516000e-07 0.7
+ 4.516100e-07 0 4.518000e-07 0 4.518100e-07 0.7 4.556000e-07 0.7 4.556100e-07 0 4.558000e-07 0
+ 4.558100e-07 0.7 4.562000e-07 0.7 4.562100e-07 0 4.596000e-07 0 4.596100e-07 0.7 4.598000e-07 0.7
+ 4.598100e-07 0 4.600000e-07 0 4.600100e-07 0.7 4.636000e-07 0.7 4.636100e-07 0 4.638000e-07 0
+ 4.638100e-07 0.7 4.676000e-07 0.7 4.676100e-07 0 4.678000e-07 0 4.678100e-07 0.7 4.682000e-07 0.7
+ 4.682100e-07 0 4.716000e-07 0 4.716100e-07 0.7 4.718000e-07 0.7 4.718100e-07 0 4.720000e-07 0
+ 4.720100e-07 0.7 4.756000e-07 0.7 4.756100e-07 0 4.758000e-07 0 4.758100e-07 0.7 4.796000e-07 0.7
+ 4.796100e-07 0 4.798000e-07 0 4.798100e-07 0.7 4.802000e-07 0.7 4.802100e-07 0 4.836000e-07 0
+ 4.836100e-07 0.7 4.838000e-07 0.7 4.838100e-07 0 4.840000e-07 0 4.840100e-07 0.7 4.876000e-07 0.7
+ 4.876100e-07 0 4.878000e-07 0 4.878100e-07 0.7 4.916000e-07 0.7 4.916100e-07 0 4.918000e-07 0
+ 4.918100e-07 0.7 4.922000e-07 0.7 4.922100e-07 0 4.956000e-07 0 4.956100e-07 0.7 4.958000e-07 0.7
+ 4.958100e-07 0 4.960000e-07 0 4.960100e-07 0.7 4.996000e-07 0.7 4.996100e-07 0 4.998000e-07 0
+ 4.998100e-07 0.7 5.036000e-07 0.7 5.036100e-07 0 5.038000e-07 0 5.038100e-07 0.7 5.042000e-07 0.7
+ 5.042100e-07 0 5.076000e-07 0 5.076100e-07 0.7 5.078000e-07 0.7 5.078100e-07 0 5.080000e-07 0
+ 5.080100e-07 0.7 5.116000e-07 0.7 5.116100e-07 0 5.118000e-07 0 5.118100e-07 0.7 5.156000e-07 0.7
+ 5.156100e-07 0 5.158000e-07 0 5.158100e-07 0.7 5.162000e-07 0.7 5.162100e-07 0 5.196000e-07 0
+ 5.196100e-07 0.7 5.198000e-07 0.7 5.198100e-07 0 5.200000e-07 0 5.200100e-07 0.7 5.236000e-07 0.7
+ 5.236100e-07 0 5.238000e-07 0 5.238100e-07 0.7 5.276000e-07 0.7 5.276100e-07 0 5.278000e-07 0
+ 5.278100e-07 0.7 5.282000e-07 0.7 5.282100e-07 0 5.316000e-07 0 5.316100e-07 0.7 5.318000e-07 0.7
+ 5.318100e-07 0 5.320000e-07 0 5.320100e-07 0.7 5.356000e-07 0.7 5.356100e-07 0 5.358000e-07 0
+ 5.358100e-07 0.7 5.396000e-07 0.7 5.396100e-07 0 5.398000e-07 0 5.398100e-07 0.7 5.402000e-07 0.7
+ 5.402100e-07 0 5.436000e-07 0 5.436100e-07 0.7 5.438000e-07 0.7 5.438100e-07 0 5.440000e-07 0
+ 5.440100e-07 0.7 5.476000e-07 0.7 5.476100e-07 0 5.478000e-07 0 5.478100e-07 0.7 5.516000e-07 0.7
+ 5.516100e-07 0 5.518000e-07 0 5.518100e-07 0.7 5.522000e-07 0.7 5.522100e-07 0 5.556000e-07 0
+ 5.556100e-07 0.7 5.558000e-07 0.7 5.558100e-07 0 5.560000e-07 0 5.560100e-07 0.7 5.596000e-07 0.7
+ 5.596100e-07 0 5.598000e-07 0 5.598100e-07 0.7 5.636000e-07 0.7 5.636100e-07 0 5.638000e-07 0
+ 5.638100e-07 0.7 5.642000e-07 0.7 5.642100e-07 0 5.676000e-07 0 5.676100e-07 0.7 5.678000e-07 0.7
+ 5.678100e-07 0 5.680000e-07 0 5.680100e-07 0.7 5.716000e-07 0.7 5.716100e-07 0 5.718000e-07 0
+ 5.718100e-07 0.7 5.756000e-07 0.7 5.756100e-07 0 5.758000e-07 0 5.758100e-07 0.7 5.762000e-07 0.7
+ 5.762100e-07 0 5.796000e-07 0 5.796100e-07 0.7 5.798000e-07 0.7 5.798100e-07 0 5.800000e-07 0
+ 5.800100e-07 0.7 5.836000e-07 0.7 5.836100e-07 0 5.838000e-07 0 5.838100e-07 0.7 5.876000e-07 0.7
+ 5.876100e-07 0 5.878000e-07 0 5.878100e-07 0.7 5.882000e-07 0.7 5.882100e-07 0 5.916000e-07 0
+ 5.916100e-07 0.7 5.918000e-07 0.7 5.918100e-07 0 5.920000e-07 0 5.920100e-07 0.7 5.956000e-07 0.7
+ 5.956100e-07 0 5.958000e-07 0 5.958100e-07 0.7 5.996000e-07 0.7 5.996100e-07 0 5.998000e-07 0
+ 5.998100e-07 0.7 6.002000e-07 0.7 6.002100e-07 0 6.036000e-07 0 6.036100e-07 0.7 6.038000e-07 0.7
+ 6.038100e-07 0 6.040000e-07 0 6.040100e-07 0.7 6.076000e-07 0.7 6.076100e-07 0 6.078000e-07 0
+ 6.078100e-07 0.7 6.116000e-07 0.7 6.116100e-07 0 6.118000e-07 0 6.118100e-07 0.7 6.122000e-07 0.7
+ 6.122100e-07 0 6.156000e-07 0 6.156100e-07 0.7 6.158000e-07 0.7 6.158100e-07 0 6.160000e-07 0
+ 6.160100e-07 0.7 6.196000e-07 0.7 6.196100e-07 0 6.198000e-07 0 6.198100e-07 0.7 6.236000e-07 0.7
+ 6.236100e-07 0 6.238000e-07 0 6.238100e-07 0.7 6.242000e-07 0.7 6.242100e-07 0 6.276000e-07 0
+ 6.276100e-07 0.7 6.278000e-07 0.7 6.278100e-07 0 6.280000e-07 0 6.280100e-07 0.7 6.316000e-07 0.7
+ 6.316100e-07 0 6.318000e-07 0 6.318100e-07 0.7 6.356000e-07 0.7 6.356100e-07 0 6.358000e-07 0
+ 6.358100e-07 0.7 6.362000e-07 0.7 6.362100e-07 0 6.396000e-07 0 6.396100e-07 0.7 6.398000e-07 0.7
+ 6.398100e-07 0 6.400000e-07 0 6.400100e-07 0.7 6.436000e-07 0.7 6.436100e-07 0 6.438000e-07 0
+ 6.438100e-07 0.7 6.476000e-07 0.7 6.476100e-07 0 6.478000e-07 0 6.478100e-07 0.7 6.482000e-07 0.7
+ 6.482100e-07 0 6.516000e-07 0 6.516100e-07 0.7 6.518000e-07 0.7 6.518100e-07 0 6.520000e-07 0
+ 6.520100e-07 0.7 6.556000e-07 0.7 6.556100e-07 0 6.558000e-07 0 6.558100e-07 0.7 6.596000e-07 0.7
+ 6.596100e-07 0 6.598000e-07 0 6.598100e-07 0.7 6.602000e-07 0.7 6.602100e-07 0 6.636000e-07 0
+ 6.636100e-07 0.7 6.638000e-07 0.7 6.638100e-07 0 6.640000e-07 0 6.640100e-07 0.7 6.676000e-07 0.7
+ 6.676100e-07 0 6.678000e-07 0 6.678100e-07 0.7 6.716000e-07 0.7 6.716100e-07 0 6.718000e-07 0
+ 6.718100e-07 0.7 6.722000e-07 0.7 6.722100e-07 0 6.756000e-07 0 6.756100e-07 0.7 6.758000e-07 0.7
+ 6.758100e-07 0 6.760000e-07 0 6.760100e-07 0.7 6.796000e-07 0.7 6.796100e-07 0 6.798000e-07 0
+ 6.798100e-07 0.7 6.836000e-07 0.7 6.836100e-07 0 6.838000e-07 0 6.838100e-07 0.7 6.842000e-07 0.7
+ 6.842100e-07 0 6.876000e-07 0 6.876100e-07 0.7 6.878000e-07 0.7 6.878100e-07 0 6.880000e-07 0
+ 6.880100e-07 0.7 6.916000e-07 0.7 6.916100e-07 0 6.918000e-07 0 6.918100e-07 0.7 6.956000e-07 0.7
+ 6.956100e-07 0 6.958000e-07 0 6.958100e-07 0.7 6.962000e-07 0.7 6.962100e-07 0 6.996000e-07 0
+ 6.996100e-07 0.7 6.998000e-07 0.7 6.998100e-07 0 7.000000e-07 0 7.000100e-07 0.7 7.036000e-07 0.7
+ 7.036100e-07 0 7.038000e-07 0 7.038100e-07 0.7 7.076000e-07 0.7 7.076100e-07 0 7.078000e-07 0
+ 7.078100e-07 0.7 7.082000e-07 0.7 7.082100e-07 0 7.116000e-07 0 7.116100e-07 0.7 7.118000e-07 0.7
+ 7.118100e-07 0 7.120000e-07 0 7.120100e-07 0.7 7.156000e-07 0.7 7.156100e-07 0 7.158000e-07 0
+ 7.158100e-07 0.7 7.196000e-07 0.7 7.196100e-07 0 7.198000e-07 0 7.198100e-07 0.7 7.202000e-07 0.7
+ 7.202100e-07 0 7.236000e-07 0 7.236100e-07 0.7 7.238000e-07 0.7 7.238100e-07 0 7.240000e-07 0
+ 7.240100e-07 0.7 7.276000e-07 0.7 7.276100e-07 0 7.278000e-07 0 7.278100e-07 0.7 7.316000e-07 0.7
+ 7.316100e-07 0 7.318000e-07 0 7.318100e-07 0.7 7.322000e-07 0.7 7.322100e-07 0 7.356000e-07 0
+ 7.356100e-07 0.7 7.358000e-07 0.7 7.358100e-07 0 7.360000e-07 0 7.360100e-07 0.7 7.396000e-07 0.7
+ 7.396100e-07 0 7.398000e-07 0 7.398100e-07 0.7 7.436000e-07 0.7 7.436100e-07 0 7.438000e-07 0
+ 7.438100e-07 0.7 7.442000e-07 0.7 7.442100e-07 0 7.476000e-07 0 7.476100e-07 0.7 7.478000e-07 0.7
+ 7.478100e-07 0 7.480000e-07 0 7.480100e-07 0.7 7.516000e-07 0.7 7.516100e-07 0 7.518000e-07 0
+ 7.518100e-07 0.7 7.556000e-07 0.7 7.556100e-07 0 7.558000e-07 0 7.558100e-07 0.7 7.562000e-07 0.7
+ 7.562100e-07 0 7.596000e-07 0 7.596100e-07 0.7 7.598000e-07 0.7 7.598100e-07 0 7.600000e-07 0
+ 7.600100e-07 0.7 7.636000e-07 0.7 7.636100e-07 0 7.638000e-07 0 7.638100e-07 0.7 7.676000e-07 0.7
+ 7.676100e-07 0 7.678000e-07 0 7.678100e-07 0.7 7.682000e-07 0.7 7.682100e-07 0 7.716000e-07 0
+ 7.716100e-07 0.7 7.718000e-07 0.7 7.718100e-07 0 7.720000e-07 0 7.720100e-07 0.7 7.756000e-07 0.7
+ 7.756100e-07 0 7.758000e-07 0 7.758100e-07 0.7 7.796000e-07 0.7 7.796100e-07 0 7.798000e-07 0
+ 7.798100e-07 0.7 7.802000e-07 0.7 7.802100e-07 0 7.836000e-07 0 7.836100e-07 0.7 7.838000e-07 0.7
+ 7.838100e-07 0 7.840000e-07 0 7.840100e-07 0.7 7.876000e-07 0.7 7.876100e-07 0 7.878000e-07 0
+ 7.878100e-07 0.7 7.916000e-07 0.7 7.916100e-07 0 7.918000e-07 0 7.918100e-07 0.7 7.922000e-07 0.7
+ 7.922100e-07 0 7.956000e-07 0 7.956100e-07 0.7 7.958000e-07 0.7 7.958100e-07 0 7.960000e-07 0
+ 7.960100e-07 0.7 7.996000e-07 0.7 7.996100e-07 0 7.998000e-07 0 7.998100e-07 0.7 8.036000e-07 0.7
+ 8.036100e-07 0 8.038000e-07 0 8.038100e-07 0.7 8.042000e-07 0.7 8.042100e-07 0 8.076000e-07 0
+ 8.076100e-07 0.7 8.078000e-07 0.7 8.078100e-07 0 8.080000e-07 0 8.080100e-07 0.7 8.116000e-07 0.7
+ 8.116100e-07 0 8.118000e-07 0 8.118100e-07 0.7 8.156000e-07 0.7 8.156100e-07 0 8.158000e-07 0
+ 8.158100e-07 0.7 8.162000e-07 0.7 8.162100e-07 0 8.196000e-07 0 8.196100e-07 0.7 8.198000e-07 0.7
+ 8.198100e-07 0 8.200000e-07 0 8.200100e-07 0.7 8.236000e-07 0.7 8.236100e-07 0 8.238000e-07 0
+ 8.238100e-07 0.7 8.276000e-07 0.7 8.276100e-07 0 8.278000e-07 0 8.278100e-07 0.7 8.282000e-07 0.7
+ 8.282100e-07 0 8.316000e-07 0 8.316100e-07 0.7 8.318000e-07 0.7 8.318100e-07 0 8.320000e-07 0
+ 8.320100e-07 0.7 8.356000e-07 0.7 8.356100e-07 0 8.358000e-07 0 8.358100e-07 0.7 8.396000e-07 0.7
+ 8.396100e-07 0 8.398000e-07 0 8.398100e-07 0.7 8.402000e-07 0.7 8.402100e-07 0 8.436000e-07 0
+ 8.436100e-07 0.7 8.438000e-07 0.7 8.438100e-07 0 8.440000e-07 0 8.440100e-07 0.7 8.476000e-07 0.7
+ 8.476100e-07 0 8.478000e-07 0 8.478100e-07 0.7 8.516000e-07 0.7 8.516100e-07 0 8.518000e-07 0
+ 8.518100e-07 0.7 8.522000e-07 0.7 8.522100e-07 0 8.556000e-07 0 8.556100e-07 0.7 8.558000e-07 0.7
+ 8.558100e-07 0 8.560000e-07 0 8.560100e-07 0.7 8.596000e-07 0.7 8.596100e-07 0 8.598000e-07 0
+ 8.598100e-07 0.7 8.636000e-07 0.7 8.636100e-07 0 8.638000e-07 0 8.638100e-07 0.7 8.642000e-07 0.7
+ 8.642100e-07 0 8.676000e-07 0 8.676100e-07 0.7 8.678000e-07 0.7 8.678100e-07 0 8.680000e-07 0
+ 8.680100e-07 0.7 8.716000e-07 0.7 8.716100e-07 0 8.718000e-07 0 8.718100e-07 0.7 8.756000e-07 0.7
+ 8.756100e-07 0 8.758000e-07 0 8.758100e-07 0.7 8.762000e-07 0.7 8.762100e-07 0 8.796000e-07 0
+ 8.796100e-07 0.7 8.798000e-07 0.7 8.798100e-07 0 8.800000e-07 0 8.800100e-07 0.7 8.836000e-07 0.7
+ 8.836100e-07 0 8.838000e-07 0 8.838100e-07 0.7 8.876000e-07 0.7 8.876100e-07 0 8.878000e-07 0
+ 8.878100e-07 0.7 8.882000e-07 0.7 8.882100e-07 0 8.916000e-07 0 8.916100e-07 0.7 8.918000e-07 0.7
+ 8.918100e-07 0 8.920000e-07 0 8.920100e-07 0.7 8.956000e-07 0.7 8.956100e-07 0 8.958000e-07 0
+ 8.958100e-07 0.7 8.996000e-07 0.7 8.996100e-07 0 8.998000e-07 0 8.998100e-07 0.7 9.002000e-07 0.7
+ 9.002100e-07 0 9.036000e-07 0 9.036100e-07 0.7 9.038000e-07 0.7 9.038100e-07 0 9.040000e-07 0
+ 9.040100e-07 0.7 9.076000e-07 0.7 9.076100e-07 0 9.078000e-07 0 9.078100e-07 0.7 9.116000e-07 0.7
+ 9.116100e-07 0 9.118000e-07 0 9.118100e-07 0.7 9.122000e-07 0.7 9.122100e-07 0 9.156000e-07 0
+ 9.156100e-07 0.7 9.158000e-07 0.7 9.158100e-07 0 9.160000e-07 0 9.160100e-07 0.7 9.196000e-07 0.7
+ 9.196100e-07 0 9.198000e-07 0 9.198100e-07 0.7 9.236000e-07 0.7 9.236100e-07 0 9.238000e-07 0
+ 9.238100e-07 0.7 9.242000e-07 0.7 9.242100e-07 0 9.276000e-07 0 9.276100e-07 0.7 9.278000e-07 0.7
+ 9.278100e-07 0 9.280000e-07 0 9.280100e-07 0.7 9.316000e-07 0.7 9.316100e-07 0 9.318000e-07 0
+ 9.318100e-07 0.7 9.356000e-07 0.7 9.356100e-07 0 9.358000e-07 0 9.358100e-07 0.7 9.362000e-07 0.7
+ 9.362100e-07 0 9.396000e-07 0 9.396100e-07 0.7 9.398000e-07 0.7 9.398100e-07 0 9.400000e-07 0
+ 9.400100e-07 0.7 9.436000e-07 0.7 9.436100e-07 0 9.438000e-07 0 9.438100e-07 0.7 9.476000e-07 0.7
+ 9.476100e-07 0 9.478000e-07 0 9.478100e-07 0.7 9.482000e-07 0.7 9.482100e-07 0 9.516000e-07 0
+ 9.516100e-07 0.7 9.518000e-07 0.7 9.518100e-07 0 9.520000e-07 0 9.520100e-07 0.7 9.556000e-07 0.7
+ 9.556100e-07 0 9.558000e-07 0 9.558100e-07 0.7 9.596000e-07 0.7 9.596100e-07 0 9.598000e-07 0
+ 9.598100e-07 0.7 9.602000e-07 0.7 9.602100e-07 0 9.636000e-07 0 9.636100e-07 0.7 9.638000e-07 0.7
+ 9.638100e-07 0 9.640000e-07 0 9.640100e-07 0.7 9.676000e-07 0.7 9.676100e-07 0 9.678000e-07 0
+ 9.678100e-07 0.7 9.716000e-07 0.7 9.716100e-07 0 9.718000e-07 0 9.718100e-07 0.7 )
v_XB1 src_XB1 0 pwl(
+ 0.000000e+00 0 4.000000e-09 0 4.010000e-09 0.7 4.200000e-09 0.7 4.210000e-09 0 8.000000e-09 0
+ 8.010000e-09 0.7 1.160000e-08 0.7 1.161000e-08 0 1.180000e-08 0 1.181000e-08 0.7 1.200000e-08 0.7
+ 1.201000e-08 0 1.600000e-08 0 1.601000e-08 0.7 1.620000e-08 0.7 1.621000e-08 0 2.000000e-08 0
+ 2.001000e-08 0.7 2.360000e-08 0.7 2.361000e-08 0 2.380000e-08 0 2.381000e-08 0.7 2.400000e-08 0.7
+ 2.401000e-08 0 2.800000e-08 0 2.801000e-08 0.7 2.820000e-08 0.7 2.821000e-08 0 3.200000e-08 0
+ 3.201000e-08 0.7 3.560000e-08 0.7 3.561000e-08 0 3.580000e-08 0 3.581000e-08 0.7 3.600000e-08 0.7
+ 3.601000e-08 0 4.000000e-08 0 4.001000e-08 0.7 4.020000e-08 0.7 4.021000e-08 0 4.400000e-08 0
+ 4.401000e-08 0.7 4.760000e-08 0.7 4.761000e-08 0 4.780000e-08 0 4.781000e-08 0.7 4.800000e-08 0.7
+ 4.801000e-08 0 5.200000e-08 0 5.201000e-08 0.7 5.220000e-08 0.7 5.221000e-08 0 5.600000e-08 0
+ 5.601000e-08 0.7 5.960000e-08 0.7 5.961000e-08 0 5.980000e-08 0 5.981000e-08 0.7 6.000000e-08 0.7
+ 6.001000e-08 0 6.400000e-08 0 6.401000e-08 0.7 6.420000e-08 0.7 6.421000e-08 0 6.800000e-08 0
+ 6.801000e-08 0.7 7.160000e-08 0.7 7.161000e-08 0 7.180000e-08 0 7.181000e-08 0.7 7.200000e-08 0.7
+ 7.201000e-08 0 7.600000e-08 0 7.601000e-08 0.7 7.620000e-08 0.7 7.621000e-08 0 8.000000e-08 0
+ 8.001000e-08 0.7 8.360000e-08 0.7 8.361000e-08 0 8.380000e-08 0 8.381000e-08 0.7 8.400000e-08 0.7
+ 8.401000e-08 0 8.800000e-08 0 8.801000e-08 0.7 8.820000e-08 0.7 8.821000e-08 0 9.200000e-08 0
+ 9.201000e-08 0.7 9.560000e-08 0.7 9.561000e-08 0 9.580000e-08 0 9.581000e-08 0.7 9.600000e-08 0.7
+ 9.601000e-08 0 1.000000e-07 0 1.000100e-07 0.7 1.002000e-07 0.7 1.002100e-07 0 1.040000e-07 0
+ 1.040100e-07 0.7 1.076000e-07 0.7 1.076100e-07 0 1.078000e-07 0 1.078100e-07 0.7 1.080000e-07 0.7
+ 1.080100e-07 0 1.120000e-07 0 1.120100e-07 0.7 1.122000e-07 0.7 1.122100e-07 0 1.160000e-07 0
+ 1.160100e-07 0.7 1.196000e-07 0.7 1.196100e-07 0 1.198000e-07 0 1.198100e-07 0.7 1.200000e-07 0.7
+ 1.200100e-07 0 1.240000e-07 0 1.240100e-07 0.7 1.242000e-07 0.7 1.242100e-07 0 1.280000e-07 0
+ 1.280100e-07 0.7 1.316000e-07 0.7 1.316100e-07 0 1.318000e-07 0 1.318100e-07 0.7 1.320000e-07 0.7
+ 1.320100e-07 0 1.360000e-07 0 1.360100e-07 0.7 1.362000e-07 0.7 1.362100e-07 0 1.400000e-07 0
+ 1.400100e-07 0.7 1.436000e-07 0.7 1.436100e-07 0 1.438000e-07 0 1.438100e-07 0.7 1.440000e-07 0.7
+ 1.440100e-07 0 1.480000e-07 0 1.480100e-07 0.7 1.482000e-07 0.7 1.482100e-07 0 1.520000e-07 0
+ 1.520100e-07 0.7 1.556000e-07 0.7 1.556100e-07 0 1.558000e-07 0 1.558100e-07 0.7 1.560000e-07 0.7
+ 1.560100e-07 0 1.600000e-07 0 1.600100e-07 0.7 1.602000e-07 0.7 1.602100e-07 0 1.640000e-07 0
+ 1.640100e-07 0.7 1.676000e-07 0.7 1.676100e-07 0 1.678000e-07 0 1.678100e-07 0.7 1.680000e-07 0.7
+ 1.680100e-07 0 1.720000e-07 0 1.720100e-07 0.7 1.722000e-07 0.7 1.722100e-07 0 1.760000e-07 0
+ 1.760100e-07 0.7 1.796000e-07 0.7 1.796100e-07 0 1.798000e-07 0 1.798100e-07 0.7 1.800000e-07 0.7
+ 1.800100e-07 0 1.840000e-07 0 1.840100e-07 0.7 1.842000e-07 0.7 1.842100e-07 0 1.880000e-07 0
+ 1.880100e-07 0.7 1.916000e-07 0.7 1.916100e-07 0 1.918000e-07 0 1.918100e-07 0.7 1.920000e-07 0.7
+ 1.920100e-07 0 1.960000e-07 0 1.960100e-07 0.7 1.962000e-07 0.7 1.962100e-07 0 2.000000e-07 0
+ 2.000100e-07 0.7 2.036000e-07 0.7 2.036100e-07 0 2.038000e-07 0 2.038100e-07 0.7 2.040000e-07 0.7
+ 2.040100e-07 0 2.080000e-07 0 2.080100e-07 0.7 2.082000e-07 0.7 2.082100e-07 0 2.120000e-07 0
+ 2.120100e-07 0.7 2.156000e-07 0.7 2.156100e-07 0 2.158000e-07 0 2.158100e-07 0.7 2.160000e-07 0.7
+ 2.160100e-07 0 2.200000e-07 0 2.200100e-07 0.7 2.202000e-07 0.7 2.202100e-07 0 2.240000e-07 0
+ 2.240100e-07 0.7 2.276000e-07 0.7 2.276100e-07 0 2.278000e-07 0 2.278100e-07 0.7 2.280000e-07 0.7
+ 2.280100e-07 0 2.320000e-07 0 2.320100e-07 0.7 2.322000e-07 0.7 2.322100e-07 0 2.360000e-07 0
+ 2.360100e-07 0.7 2.396000e-07 0.7 2.396100e-07 0 2.398000e-07 0 2.398100e-07 0.7 2.400000e-07 0.7
+ 2.400100e-07 0 2.440000e-07 0 2.440100e-07 0.7 2.442000e-07 0.7 2.442100e-07 0 2.480000e-07 0
+ 2.480100e-07 0.7 2.516000e-07 0.7 2.516100e-07 0 2.518000e-07 0 2.518100e-07 0.7 2.520000e-07 0.7
+ 2.520100e-07 0 2.560000e-07 0 2.560100e-07 0.7 2.562000e-07 0.7 2.562100e-07 0 2.600000e-07 0
+ 2.600100e-07 0.7 2.636000e-07 0.7 2.636100e-07 0 2.638000e-07 0 2.638100e-07 0.7 2.640000e-07 0.7
+ 2.640100e-07 0 2.680000e-07 0 2.680100e-07 0.7 2.682000e-07 0.7 2.682100e-07 0 2.720000e-07 0
+ 2.720100e-07 0.7 2.756000e-07 0.7 2.756100e-07 0 2.758000e-07 0 2.758100e-07 0.7 2.760000e-07 0.7
+ 2.760100e-07 0 2.800000e-07 0 2.800100e-07 0.7 2.802000e-07 0.7 2.802100e-07 0 2.840000e-07 0
+ 2.840100e-07 0.7 2.876000e-07 0.7 2.876100e-07 0 2.878000e-07 0 2.878100e-07 0.7 2.880000e-07 0.7
+ 2.880100e-07 0 2.920000e-07 0 2.920100e-07 0.7 2.922000e-07 0.7 2.922100e-07 0 2.960000e-07 0
+ 2.960100e-07 0.7 2.996000e-07 0.7 2.996100e-07 0 2.998000e-07 0 2.998100e-07 0.7 3.000000e-07 0.7
+ 3.000100e-07 0 3.040000e-07 0 3.040100e-07 0.7 3.042000e-07 0.7 3.042100e-07 0 3.080000e-07 0
+ 3.080100e-07 0.7 3.116000e-07 0.7 3.116100e-07 0 3.118000e-07 0 3.118100e-07 0.7 3.120000e-07 0.7
+ 3.120100e-07 0 3.160000e-07 0 3.160100e-07 0.7 3.162000e-07 0.7 3.162100e-07 0 3.200000e-07 0
+ 3.200100e-07 0.7 3.236000e-07 0.7 3.236100e-07 0 3.238000e-07 0 3.238100e-07 0.7 3.240000e-07 0.7
+ 3.240100e-07 0 3.280000e-07 0 3.280100e-07 0.7 3.282000e-07 0.7 3.282100e-07 0 3.320000e-07 0
+ 3.320100e-07 0.7 3.356000e-07 0.7 3.356100e-07 0 3.358000e-07 0 3.358100e-07 0.7 3.360000e-07 0.7
+ 3.360100e-07 0 3.400000e-07 0 3.400100e-07 0.7 3.402000e-07 0.7 3.402100e-07 0 3.440000e-07 0
+ 3.440100e-07 0.7 3.476000e-07 0.7 3.476100e-07 0 3.478000e-07 0 3.478100e-07 0.7 3.480000e-07 0.7
+ 3.480100e-07 0 3.520000e-07 0 3.520100e-07 0.7 3.522000e-07 0.7 3.522100e-07 0 3.560000e-07 0
+ 3.560100e-07 0.7 3.596000e-07 0.7 3.596100e-07 0 3.598000e-07 0 3.598100e-07 0.7 3.600000e-07 0.7
+ 3.600100e-07 0 3.640000e-07 0 3.640100e-07 0.7 3.642000e-07 0.7 3.642100e-07 0 3.680000e-07 0
+ 3.680100e-07 0.7 3.716000e-07 0.7 3.716100e-07 0 3.718000e-07 0 3.718100e-07 0.7 3.720000e-07 0.7
+ 3.720100e-07 0 3.760000e-07 0 3.760100e-07 0.7 3.762000e-07 0.7 3.762100e-07 0 3.800000e-07 0
+ 3.800100e-07 0.7 3.836000e-07 0.7 3.836100e-07 0 3.838000e-07 0 3.838100e-07 0.7 3.840000e-07 0.7
+ 3.840100e-07 0 3.880000e-07 0 3.880100e-07 0.7 3.882000e-07 0.7 3.882100e-07 0 3.920000e-07 0
+ 3.920100e-07 0.7 3.956000e-07 0.7 3.956100e-07 0 3.958000e-07 0 3.958100e-07 0.7 3.960000e-07 0.7
+ 3.960100e-07 0 4.000000e-07 0 4.000100e-07 0.7 4.002000e-07 0.7 4.002100e-07 0 4.040000e-07 0
+ 4.040100e-07 0.7 4.076000e-07 0.7 4.076100e-07 0 4.078000e-07 0 4.078100e-07 0.7 4.080000e-07 0.7
+ 4.080100e-07 0 4.120000e-07 0 4.120100e-07 0.7 4.122000e-07 0.7 4.122100e-07 0 4.160000e-07 0
+ 4.160100e-07 0.7 4.196000e-07 0.7 4.196100e-07 0 4.198000e-07 0 4.198100e-07 0.7 4.200000e-07 0.7
+ 4.200100e-07 0 4.240000e-07 0 4.240100e-07 0.7 4.242000e-07 0.7 4.242100e-07 0 4.280000e-07 0
+ 4.280100e-07 0.7 4.316000e-07 0.7 4.316100e-07 0 4.318000e-07 0 4.318100e-07 0.7 4.320000e-07 0.7
+ 4.320100e-07 0 4.360000e-07 0 4.360100e-07 0.7 4.362000e-07 0.7 4.362100e-07 0 4.400000e-07 0
+ 4.400100e-07 0.7 4.436000e-07 0.7 4.436100e-07 0 4.438000e-07 0 4.438100e-07 0.7 4.440000e-07 0.7
+ 4.440100e-07 0 4.480000e-07 0 4.480100e-07 0.7 4.482000e-07 0.7 4.482100e-07 0 4.520000e-07 0
+ 4.520100e-07 0.7 4.556000e-07 0.7 4.556100e-07 0 4.558000e-07 0 4.558100e-07 0.7 4.560000e-07 0.7
+ 4.560100e-07 0 4.600000e-07 0 4.600100e-07 0.7 4.602000e-07 0.7 4.602100e-07 0 4.640000e-07 0
+ 4.640100e-07 0.7 4.676000e-07 0.7 4.676100e-07 0 4.678000e-07 0 4.678100e-07 0.7 4.680000e-07 0.7
+ 4.680100e-07 0 4.720000e-07 0 4.720100e-07 0.7 4.722000e-07 0.7 4.722100e-07 0 4.760000e-07 0
+ 4.760100e-07 0.7 4.796000e-07 0.7 4.796100e-07 0 4.798000e-07 0 4.798100e-07 0.7 4.800000e-07 0.7
+ 4.800100e-07 0 4.840000e-07 0 4.840100e-07 0.7 4.842000e-07 0.7 4.842100e-07 0 4.880000e-07 0
+ 4.880100e-07 0.7 4.916000e-07 0.7 4.916100e-07 0 4.918000e-07 0 4.918100e-07 0.7 4.920000e-07 0.7
+ 4.920100e-07 0 4.960000e-07 0 4.960100e-07 0.7 4.962000e-07 0.7 4.962100e-07 0 5.000000e-07 0
+ 5.000100e-07 0.7 5.036000e-07 0.7 5.036100e-07 0 5.038000e-07 0 5.038100e-07 0.7 5.040000e-07 0.7
+ 5.040100e-07 0 5.080000e-07 0 5.080100e-07 0.7 5.082000e-07 0.7 5.082100e-07 0 5.120000e-07 0
+ 5.120100e-07 0.7 5.156000e-07 0.7 5.156100e-07 0 5.158000e-07 0 5.158100e-07 0.7 5.160000e-07 0.7
+ 5.160100e-07 0 5.200000e-07 0 5.200100e-07 0.7 5.202000e-07 0.7 5.202100e-07 0 5.240000e-07 0
+ 5.240100e-07 0.7 5.276000e-07 0.7 5.276100e-07 0 5.278000e-07 0 5.278100e-07 0.7 5.280000e-07 0.7
+ 5.280100e-07 0 5.320000e-07 0 5.320100e-07 0.7 5.322000e-07 0.7 5.322100e-07 0 5.360000e-07 0
+ 5.360100e-07 0.7 5.396000e-07 0.7 5.396100e-07 0 5.398000e-07 0 5.398100e-07 0.7 5.400000e-07 0.7
+ 5.400100e-07 0 5.440000e-07 0 5.440100e-07 0.7 5.442000e-07 0.7 5.442100e-07 0 5.480000e-07 0
+ 5.480100e-07 0.7 5.516000e-07 0.7 5.516100e-07 0 5.518000e-07 0 5.518100e-07 0.7 5.520000e-07 0.7
+ 5.520100e-07 0 5.560000e-07 0 5.560100e-07 0.7 5.562000e-07 0.7 5.562100e-07 0 5.600000e-07 0
+ 5.600100e-07 0.7 5.636000e-07 0.7 5.636100e-07 0 5.638000e-07 0 5.638100e-07 0.7 5.640000e-07 0.7
+ 5.640100e-07 0 5.680000e-07 0 5.680100e-07 0.7 5.682000e-07 0.7 5.682100e-07 0 5.720000e-07 0
+ 5.720100e-07 0.7 5.756000e-07 0.7 5.756100e-07 0 5.758000e-07 0 5.758100e-07 0.7 5.760000e-07 0.7
+ 5.760100e-07 0 5.800000e-07 0 5.800100e-07 0.7 5.802000e-07 0.7 5.802100e-07 0 5.840000e-07 0
+ 5.840100e-07 0.7 5.876000e-07 0.7 5.876100e-07 0 5.878000e-07 0 5.878100e-07 0.7 5.880000e-07 0.7
+ 5.880100e-07 0 5.920000e-07 0 5.920100e-07 0.7 5.922000e-07 0.7 5.922100e-07 0 5.960000e-07 0
+ 5.960100e-07 0.7 5.996000e-07 0.7 5.996100e-07 0 5.998000e-07 0 5.998100e-07 0.7 6.000000e-07 0.7
+ 6.000100e-07 0 6.040000e-07 0 6.040100e-07 0.7 6.042000e-07 0.7 6.042100e-07 0 6.080000e-07 0
+ 6.080100e-07 0.7 6.116000e-07 0.7 6.116100e-07 0 6.118000e-07 0 6.118100e-07 0.7 6.120000e-07 0.7
+ 6.120100e-07 0 6.160000e-07 0 6.160100e-07 0.7 6.162000e-07 0.7 6.162100e-07 0 6.200000e-07 0
+ 6.200100e-07 0.7 6.236000e-07 0.7 6.236100e-07 0 6.238000e-07 0 6.238100e-07 0.7 6.240000e-07 0.7
+ 6.240100e-07 0 6.280000e-07 0 6.280100e-07 0.7 6.282000e-07 0.7 6.282100e-07 0 6.320000e-07 0
+ 6.320100e-07 0.7 6.356000e-07 0.7 6.356100e-07 0 6.358000e-07 0 6.358100e-07 0.7 6.360000e-07 0.7
+ 6.360100e-07 0 6.400000e-07 0 6.400100e-07 0.7 6.402000e-07 0.7 6.402100e-07 0 6.440000e-07 0
+ 6.440100e-07 0.7 6.476000e-07 0.7 6.476100e-07 0 6.478000e-07 0 6.478100e-07 0.7 6.480000e-07 0.7
+ 6.480100e-07 0 6.520000e-07 0 6.520100e-07 0.7 6.522000e-07 0.7 6.522100e-07 0 6.560000e-07 0
+ 6.560100e-07 0.7 6.596000e-07 0.7 6.596100e-07 0 6.598000e-07 0 6.598100e-07 0.7 6.600000e-07 0.7
+ 6.600100e-07 0 6.640000e-07 0 6.640100e-07 0.7 6.642000e-07 0.7 6.642100e-07 0 6.680000e-07 0
+ 6.680100e-07 0.7 6.716000e-07 0.7 6.716100e-07 0 6.718000e-07 0 6.718100e-07 0.7 6.720000e-07 0.7
+ 6.720100e-07 0 6.760000e-07 0 6.760100e-07 0.7 6.762000e-07 0.7 6.762100e-07 0 6.800000e-07 0
+ 6.800100e-07 0.7 6.836000e-07 0.7 6.836100e-07 0 6.838000e-07 0 6.838100e-07 0.7 6.840000e-07 0.7
+ 6.840100e-07 0 6.880000e-07 0 6.880100e-07 0.7 6.882000e-07 0.7 6.882100e-07 0 6.920000e-07 0
+ 6.920100e-07 0.7 6.956000e-07 0.7 6.956100e-07 0 6.958000e-07 0 6.958100e-07 0.7 6.960000e-07 0.7
+ 6.960100e-07 0 7.000000e-07 0 7.000100e-07 0.7 7.002000e-07 0.7 7.002100e-07 0 7.040000e-07 0
+ 7.040100e-07 0.7 7.076000e-07 0.7 7.076100e-07 0 7.078000e-07 0 7.078100e-07 0.7 7.080000e-07 0.7
+ 7.080100e-07 0 7.120000e-07 0 7.120100e-07 0.7 7.122000e-07 0.7 7.122100e-07 0 7.160000e-07 0
+ 7.160100e-07 0.7 7.196000e-07 0.7 7.196100e-07 0 7.198000e-07 0 7.198100e-07 0.7 7.200000e-07 0.7
+ 7.200100e-07 0 7.240000e-07 0 7.240100e-07 0.7 7.242000e-07 0.7 7.242100e-07 0 7.280000e-07 0
+ 7.280100e-07 0.7 7.316000e-07 0.7 7.316100e-07 0 7.318000e-07 0 7.318100e-07 0.7 7.320000e-07 0.7
+ 7.320100e-07 0 7.360000e-07 0 7.360100e-07 0.7 7.362000e-07 0.7 7.362100e-07 0 7.400000e-07 0
+ 7.400100e-07 0.7 7.436000e-07 0.7 7.436100e-07 0 7.438000e-07 0 7.438100e-07 0.7 7.440000e-07 0.7
+ 7.440100e-07 0 7.480000e-07 0 7.480100e-07 0.7 7.482000e-07 0.7 7.482100e-07 0 7.520000e-07 0
+ 7.520100e-07 0.7 7.556000e-07 0.7 7.556100e-07 0 7.558000e-07 0 7.558100e-07 0.7 7.560000e-07 0.7
+ 7.560100e-07 0 7.600000e-07 0 7.600100e-07 0.7 7.602000e-07 0.7 7.602100e-07 0 7.640000e-07 0
+ 7.640100e-07 0.7 7.676000e-07 0.7 7.676100e-07 0 7.678000e-07 0 7.678100e-07 0.7 7.680000e-07 0.7
+ 7.680100e-07 0 7.720000e-07 0 7.720100e-07 0.7 7.722000e-07 0.7 7.722100e-07 0 7.760000e-07 0
+ 7.760100e-07 0.7 7.796000e-07 0.7 7.796100e-07 0 7.798000e-07 0 7.798100e-07 0.7 7.800000e-07 0.7
+ 7.800100e-07 0 7.840000e-07 0 7.840100e-07 0.7 7.842000e-07 0.7 7.842100e-07 0 7.880000e-07 0
+ 7.880100e-07 0.7 7.916000e-07 0.7 7.916100e-07 0 7.918000e-07 0 7.918100e-07 0.7 7.920000e-07 0.7
+ 7.920100e-07 0 7.960000e-07 0 7.960100e-07 0.7 7.962000e-07 0.7 7.962100e-07 0 8.000000e-07 0
+ 8.000100e-07 0.7 8.036000e-07 0.7 8.036100e-07 0 8.038000e-07 0 8.038100e-07 0.7 8.040000e-07 0.7
+ 8.040100e-07 0 8.080000e-07 0 8.080100e-07 0.7 8.082000e-07 0.7 8.082100e-07 0 8.120000e-07 0
+ 8.120100e-07 0.7 8.156000e-07 0.7 8.156100e-07 0 8.158000e-07 0 8.158100e-07 0.7 8.160000e-07 0.7
+ 8.160100e-07 0 8.200000e-07 0 8.200100e-07 0.7 8.202000e-07 0.7 8.202100e-07 0 8.240000e-07 0
+ 8.240100e-07 0.7 8.276000e-07 0.7 8.276100e-07 0 8.278000e-07 0 8.278100e-07 0.7 8.280000e-07 0.7
+ 8.280100e-07 0 8.320000e-07 0 8.320100e-07 0.7 8.322000e-07 0.7 8.322100e-07 0 8.360000e-07 0
+ 8.360100e-07 0.7 8.396000e-07 0.7 8.396100e-07 0 8.398000e-07 0 8.398100e-07 0.7 8.400000e-07 0.7
+ 8.400100e-07 0 8.440000e-07 0 8.440100e-07 0.7 8.442000e-07 0.7 8.442100e-07 0 8.480000e-07 0
+ 8.480100e-07 0.7 8.516000e-07 0.7 8.516100e-07 0 8.518000e-07 0 8.518100e-07 0.7 8.520000e-07 0.7
+ 8.520100e-07 0 8.560000e-07 0 8.560100e-07 0.7 8.562000e-07 0.7 8.562100e-07 0 8.600000e-07 0
+ 8.600100e-07 0.7 8.636000e-07 0.7 8.636100e-07 0 8.638000e-07 0 8.638100e-07 0.7 8.640000e-07 0.7
+ 8.640100e-07 0 8.680000e-07 0 8.680100e-07 0.7 8.682000e-07 0.7 8.682100e-07 0 8.720000e-07 0
+ 8.720100e-07 0.7 8.756000e-07 0.7 8.756100e-07 0 8.758000e-07 0 8.758100e-07 0.7 8.760000e-07 0.7
+ 8.760100e-07 0 8.800000e-07 0 8.800100e-07 0.7 8.802000e-07 0.7 8.802100e-07 0 8.840000e-07 0
+ 8.840100e-07 0.7 8.876000e-07 0.7 8.876100e-07 0 8.878000e-07 0 8.878100e-07 0.7 8.880000e-07 0.7
+ 8.880100e-07 0 8.920000e-07 0 8.920100e-07 0.7 8.922000e-07 0.7 8.922100e-07 0 8.960000e-07 0
+ 8.960100e-07 0.7 8.996000e-07 0.7 8.996100e-07 0 8.998000e-07 0 8.998100e-07 0.7 9.000000e-07 0.7
+ 9.000100e-07 0 9.040000e-07 0 9.040100e-07 0.7 9.042000e-07 0.7 9.042100e-07 0 9.080000e-07 0
+ 9.080100e-07 0.7 9.116000e-07 0.7 9.116100e-07 0 9.118000e-07 0 9.118100e-07 0.7 9.120000e-07 0.7
+ 9.120100e-07 0 9.160000e-07 0 9.160100e-07 0.7 9.162000e-07 0.7 9.162100e-07 0 9.200000e-07 0
+ 9.200100e-07 0.7 9.236000e-07 0.7 9.236100e-07 0 9.238000e-07 0 9.238100e-07 0.7 9.240000e-07 0.7
+ 9.240100e-07 0 9.280000e-07 0 9.280100e-07 0.7 9.282000e-07 0.7 9.282100e-07 0 9.320000e-07 0
+ 9.320100e-07 0.7 9.356000e-07 0.7 9.356100e-07 0 9.358000e-07 0 9.358100e-07 0.7 9.360000e-07 0.7
+ 9.360100e-07 0 9.400000e-07 0 9.400100e-07 0.7 9.402000e-07 0.7 9.402100e-07 0 9.440000e-07 0
+ 9.440100e-07 0.7 9.476000e-07 0.7 9.476100e-07 0 9.478000e-07 0 9.478100e-07 0.7 9.480000e-07 0.7
+ 9.480100e-07 0 9.520000e-07 0 9.520100e-07 0.7 9.522000e-07 0.7 9.522100e-07 0 9.560000e-07 0
+ 9.560100e-07 0.7 9.596000e-07 0.7 9.596100e-07 0 9.598000e-07 0 9.598100e-07 0.7 9.600000e-07 0.7
+ 9.600100e-07 0 9.640000e-07 0 9.640100e-07 0.7 9.642000e-07 0.7 9.642100e-07 0 9.680000e-07 0
+ 9.680100e-07 0.7 9.716000e-07 0.7 9.716100e-07 0 9.718000e-07 0 9.718100e-07 0.7 9.720000e-07 0.7
+ 9.720100e-07 0 )
xd1_B0 src_B0 mid_B0 VDD VSS INV
xd2_B0 mid_B0 B0 VDD VSS INV
xd1_B1 src_B1 mid_B1 VDD VSS INV
xd2_B1 mid_B1 B1 VDD VSS INV
xd1_WA0 src_WA0 mid_WA0 VDD VSS INV
xd2_WA0 mid_WA0 WA0 VDD VSS INV
xd1_WA1 src_WA1 mid_WA1 VDD VSS INV
xd2_WA1 mid_WA1 WA1 VDD VSS INV
xd1_WB0 src_WB0 mid_WB0 VDD VSS INV
xd2_WB0 mid_WB0 WB0 VDD VSS INV
xd1_WB1 src_WB1 mid_WB1 VDD VSS INV
xd2_WB1 mid_WB1 WB1 VDD VSS INV
xd1_XA0 src_XA0 mid_XA0 VDD VSS INV
xd2_XA0 mid_XA0 XA0 VDD VSS INV
xd1_XA1 src_XA1 mid_XA1 VDD VSS INV
xd2_XA1 mid_XA1 XA1 VDD VSS INV
xd1_XB0 src_XB0 mid_XB0 VDD VSS INV
xd2_XB0 mid_XB0 XB0 VDD VSS INV
xd1_XB1 src_XB1 mid_XB1 VDD VSS INV
xd2_XB1 mid_XB1 XB1 VDD VSS INV

xdut B0 B1 VDD VSS WA0 WA1 WB0 WB1 XA0 XA1 XB0 XB1 Z0 Z1 NEURON
* FO4 load on each output
xl0_Z0 Z0 lo0_Z0 VDD VSS INV
xl1_Z0 Z0 lo1_Z0 VDD VSS INV
xl2_Z0 Z0 lo2_Z0 VDD VSS INV
xl3_Z0 Z0 lo3_Z0 VDD VSS INV
xl0_Z1 Z1 lo0_Z1 VDD VSS INV
xl1_Z1 Z1 lo1_Z1 VDD VSS INV
xl2_Z1 Z1 lo2_Z1 VDD VSS INV
xl3_Z1 Z1 lo3_Z1 VDD VSS INV

.tran 1p 972400p
.end
